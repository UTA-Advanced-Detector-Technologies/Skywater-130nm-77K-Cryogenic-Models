.include "./skywater-pdk/libraries/sky130_fd_pr/latest/models/parameters/lod.spice"
.param mc_mm_switch = 0
.param mc_pr_switch = 0
.option scale=1.0u
.param my_gauss = AGAUSS(0,1.0,1)
.param lv_dlc_rotweak = 0
.param lvhvt_dlc_rotweak = 0
.param lvt_dlc_rotweak = 0
.param hv_dlc_rotweak = 0
.param sky130_fd_pr__nfet_01v8__dlc_rotweak = lv_dlc_rotweak
.param sky130_fd_pr__esd_nfet_01v8__dlc_rotweak = lv_dlc_rotweak
.param sky130_fd_pr__nfet_01v8_lvt__dlc_rotweak = lvt_dlc_rotweak
.param sky130_fd_pr__pfet_01v8__dlc_rotweak = lv_dlc_rotweak
.param sky130_fd_pr__pfet_01v8_lvt__dlc_rotweak = lvt_dlc_rotweak
.param sky130_fd_pr__pfet_01v8_hvt__dlc_rotweak = lvhvt_dlc_rotweak
.param sky130_fd_pr__esd_nfet_g5v0d10v5__dlc_rotweak = hv_dlc_rotweak
.param sky130_fd_pr__esd_pfet_g5v0d10v5__dlc_rotweak = hv_dlc_rotweak
.param sky130_fd_pr__nfet_03v3_nvt__dlc_rotweak = hv_dlc_rotweak
.param sky130_fd_pr__nfet_05v0_nvt__dlc_rotweak = hv_dlc_rotweak
.param sky130_fd_pr__nfet_g5v0d10v5__dlc_rotweak = hv_dlc_rotweak
.param sky130_fd_pr__pfet_g5v0d10v5__dlc_rotweak = hv_dlc_rotweak
.param sky130_fd_pr__pfet_g5v0d16v0__dlc_rotweak = hv_dlc_rotweak
.param sky130_fd_pr__special_nfet_pass__dlc_rotweak = lv_dlc_rotweak
.param sky130_fd_pr__special_nfet_pass_lowleakage__dlc_rotweak = lv_dlc_rotweak
.param sky130_fd_pr__special_nfet_pass_flash__dlc_rotweak = hv_dlc_rotweak
.param sky130_fd_pr__special_nfet_latch__dlc_rotweak = lv_dlc_rotweak
.param sky130_fd_pr__special_nfet_latch_lowleakage__dlc_rotweak = lv_dlc_rotweak
.param sky130_fd_pr__special_pfet_pass__dlc_rotweak = lv_dlc_rotweak
.param sky130_fd_pr__special_pfet_pass_lowleakage__dlc_rotweak = lv_dlc_rotweak
.param sky130_fd_bs_flash__special_sonosfet_star__dlc_rotweak = hv_dlc_rotweak
.param sky130_fd_bs_flash__special_sonosfet_original__dlc_rotweak = hv_dlc_rotweak
.param sonos_eeol_dlc_rotweak = hv_dlc_rotweak
.param sonos_peol_dlc_rotweak = hv_dlc_rotweak
.param sky130_fd_pr__pfet_01v8_lvt__toxe_slope = 0.003689
.param sky130_fd_pr__pfet_01v8_lvt__toxe_slope1 = 0.01489
.param sky130_fd_pr__pfet_01v8_lvt__toxe_slope2 = 0.01689
.param sky130_fd_pr__pfet_01v8_lvt__toxe_slope3 = 0.02389
.param sky130_fd_pr__pfet_01v8_lvt__vth0_slope = 0.01389
.param sky130_fd_pr__pfet_01v8_lvt__vth0_slope1 = 0.009789
.param sky130_fd_pr__pfet_01v8_lvt__vth0_slope2 = 0.01089
.param sky130_fd_pr__pfet_01v8_lvt__lint_slope = 0
.param sky130_fd_pr__pfet_01v8_lvt__wint_slope = 0
.param sky130_fd_pr__pfet_01v8_lvt__nfactor_slope = 0
.param sky130_fd_pr__pfet_01v8_lvt__voff_slope = 0
.param sky130_fd_pr__pfet_01v8_lvt__ajunction_mult = 0.99626
.param sky130_fd_pr__pfet_01v8_lvt__pjunction_mult = 1.0009
.param sky130_fd_pr__pfet_01v8_lvt__toxe_slope_spectre = 0
.param sky130_fd_pr__pfet_01v8_lvt__vth0_slope_spectre = 0
.param sky130_fd_pr__pfet_01v8_lvt__voff_slope_spectre = 0
.param sky130_fd_pr__pfet_01v8_lvt__nfactor_slope_spectre = 0

.subckt sky130_fd_pr__pfet_01v8_lvt d g s b
.param l=1 w=1 ad=0 as=0 pd= 0 ps=0 nrd=0 nrs=0 sa = 0 sb = 0 sd = 0 m = 1 nf=1.0 m = 1
msky130_fd_pr__pfet_01v8_lvt d g s b sky130_fd_pr__pfet_01v8_lvt__model l = {l} w = {w} ad = {ad} as = {as} pd = {pd} ps = {ps} nrd = {nrd} nrs = {nrs} sa = {sa} sb = {sb} sd = {sd} nf = {nf}
.param vth0_nom = 2.08113
.param dvt0_nom = 1
.param dvt1_nom = 1
.param vsat_nom = 9999.92
.param ua_nom = 1
.param ub_nom = 1
.param uc_nom = 1
.param rdsw_nom = 1.11407e-05
.param prwg_nom = 1
.param u0_nom = 3.41512
.param rdw_nom = 1
.param rsw_nom = 1
.param nfactor_nom = 13.5087
.param eta0_nom = 1
.param dsub_nom = 1
.param pclm_nom = 1
.param pvag_nom = 1
.param delta_nom = 1
.model sky130_fd_pr__pfet_01v8_lvt__model.0 pmos
+lmin=1.5e-07
+lmax=5e-07
+wmin=1e-06
+wmax=3e-06
+level=54
+tnom=-196.15
+version=4.82
+toxm=4.23e-09
+xj=1.5e-07
+lln=1
+lwn=1
+wln=1
+wwn=1
+lint=2.8e-09
+ll=0
+lw=0
+lwl=0
+wint=7.476e-09
+wl=0
+ww=0
+wwl=0
+xl=0
+xw=0
+mobmod=0
+binunit=2
+dwg=-7.916e-09
+dwb=0
+igcmod=0
+igbmod=0
+rgatemod=0
+rbodymod=1
+trnqsmod=0
+acnqsmod=0
+fnoimod=1
*+tnoimod=1
+permod=1
+geomod=0
+rdsmod=0
+tempmod=0
+lintnoi=0
+vfbsdoff=0
+lambda=0
+vtl=0
+lc=5e-09
+xn=3
+rnoia=0.69
+rnoib=0.34
+tnoia=2.5e+07
+tnoib=0
+epsrox=3.9
+toxe={4.23e-09+MC_MM_SWITCH*my_gauss*(4.23e-09*(sky130_fd_pr__pfet_01v8_lvt__toxe_slope3/sqrt(l*w*m)))}
+dtox=0
+ndep=1.7e+17
+nsd=1e+20
+rshg=0.1
+rsh=1
+vth0={(-5.458335523e-01+MC_MM_SWITCH*my_gauss*(sky130_fd_pr__pfet_01v8_lvt__vth0_slope/sqrt(l*w*m)))*vth0_nom}
+lvth0=4.78763e-08
+wvth0=2.2721e-07
+pvth0=-6.87602e-14
+k1=0.64774
+k2=-0.0928809
+lk2=1.88911e-08
+wk2=3.47563e-08
+pk2=-8.52373e-15
+k3=3.39
+dvt0={2.4422*dvt0_nom}
+dvt1={0.16136*dvt1_nom}
+dvt2=0.026237
+dvt0w=0.5
+dvt1w=1.9281e+06
+dvt2w=-0.032
+w0=1e-08
+k3b=1
+phin=0
+lpe0=0
+lpeb=0
+vbm=-3
+dvtp0=0
+dvtp1=0
+vsat={1.027510387e+05*vsat_nom}
+lvsat=0.0103597
+wvsat=0.00611451
+pvsat=-1.23405e-08
+ua={-2.321180996e-09*ua_nom}
+lua=-2.14828e-16
+wua=-5.05604e-16
+pua=1.6689e-22
+ub='2.016844244e-18*ub_nom'
+lub=4.25324e-25
+wub=5.06872e-25
+pub=-1.7006e-31
+uc={1.174942768e-10*uc_nom}
+luc=-2.41394e-17
+wuc=-5.97513e-17
+puc=2.37784e-23
+rdsw={484.7*rdsw_nom}
+prwb=0.1
+prwg={0.052*prwg_nom}
+wr=1
+u0={3.487838784e-03*u0_nom}
+lu0=-4.9634e-11
+wu0=-1.34533e-09
+pu0=2.93897e-16
+a0=2.03763
+la0=-1.3103e-07
+wa0=-8.6185e-07
+pa0=1.29071e-13
+keta=-0.0117262
+lketa=-4.22109e-10
+wketa=-2.54858e-09
+pketa=1.26002e-15
+a1=0
+a2=0.467037
+ags=0.330004
+wags=-7.1952e-08
+b0=-5.42344e-06
+lb0=1.89759e-12
+wb0=5.38139e-12
+pb0=-1.94219e-18
+b1=5.12746e-08
+lb1=-5.25763e-14
+wb1=-1.53057e-13
+pb1=1.56943e-19
+eu=1.67
+rdswmin=0
+rdw={1e-12*rdw_nom}
+rdwmin=0
+rsw={1e-12*rsw_nom}
+rswmin=0
+voff={-0.1819+MC_MM_SWITCH*my_gauss*(sky130_fd_pr__pfet_01v8_lvt__voff_slope/sqrt(l*w*m))}
+nfactor={(4.667430253e+00+MC_MM_SWITCH*my_gauss*(sky130_fd_pr__pfet_01v8_lvt__nfactor_slope/sqrt(l*w*m)))*nfactor_nom}
+wnfactor=-2.09828e-06
+up=0
+ud=0
+lp=1
+tvfbsdoff=0
+tvoff=0
+cit=-6.39311e-11
+cdsc=2.8125e-07
+cdscb=0.0001
+cdscd=1e-10
+eta0={0.2*eta0_nom}
+etab=-0.00025
+dsub={1.0*dsub_nom}
+voffl=0
+minv=0
+pclm='0.030097*pclm_nom'
+pdiblc1=0
+pdiblc2=-0.0966654
+lpdiblc2=6.78966e-08
+wpdiblc2=4.76568e-08
+ppdiblc2=-1.92374e-14
+pdiblcb=-0.025
+drout=0.43496
+pscbe1=8e+08
+pscbe2=8.6797e-09
+pvag={1e-12*pvag_nom}
+delta={-1.535133613e-02*delta_nom}
+ldelta=4.15317e-08
+wdelta=9.8404e-08
+pdelta=-5.19727e-14
+alpha0=5.04495e-13
+alpha1=-4.05837e-18
+beta0=6.20165
+fprout=0
+pdits=0
+pditsl=0
+pditsd=0
+agidl=0
+bgidl=2.3e+09
+cgidl=0.5
+egidl=0.8
+aigbacc=0.43
+bigbacc=0.054
+cigbacc=0.075
+nigbacc=1
+aigbinv=0.35
+bigbinv=0.03
+cigbinv=0.006
+eigbinv=1.1
+nigbinv=3
+aigc=0.43
+bigc=0.054
+cigc=0.075
+nigc=1
+aigsd=0.43
+bigsd=0.054
+cigsd=0.075
+dlcig=0
+poxedge=1
+pigcd=1
+ntox=1
+toxref=4.23e-09
+kt1=0
+lkt1=0
+wkt1=0
+pkt1=0
+kt2=0
+lkt2=0
+wkt2=0
+pkt2=0
+at=0
+lat=0
+wat=0
+pat=0
+ute=0
+lute=0
+wute=0
+pute=0
+ua1=0
+lua1=0
+wua1=0
+pua1=0
+ub1=0
+lub1=0
+wub1=0
+pub1=0
+uc1=0
+luc1=0
+wuc1=0
+puc1=0
+kt1l=0
+prt=0
+xrcrg1=12
+xrcrg2=1
+rbpb=50
+rbpd=50
+rbps=50
+rbdb=50
+rbsb=50
+gbmin=1e-12
+noia=3e+41
+noib=0
+noic=0
+em=4.1e+07
+af=1
+ef=0.88
+kf=0
+ntnoi=1
+dmcg=0
+dmcgt=0
+dmdg=0
+xgw=0
+xgl=0
+ngcon=1
+diomod=1
+njs=1.3632
+jss=2.1483e-05
+jsws=1.4472e-10
+xtis=0
+bvs=12.69
+xjbvs=1
+ijthsrev=0.1
+ijthsfwd=0.1
+tpb=0.001671
+tpbsw=0.001246
+tpbswg=0
+tcj=0.0012407
+tcjsw=0.00037357
+tcjswg=2e-12
+cgdo=2e-11
+cgso=2e-11
+cgbo=1e-13
+capmod=2
+xpart=0
+cgsl=0
+cgdl=0
+cf=0
+clc=7e-08
+cle=0.492
+dlc=-1.2e-08
+dwc=0
+vfbcv=-1
+acde=0.44
+moin=8.7
+noff=2.6123
+voffcv=0.112
+ngate=1e+23
+lwc=0
+llc=0
+lwlc=0
+wlc=0
+wwc=0
+wwlc=0
+ckappas=0.6
+cjs=0.000765357
+mjs=0.3362
+pbs=0.6587
+cjsws=9.16024e-11
+mjsws=0.2659
+pbsws=0.7418
+cjswgs=2.39155e-10
+mjswgs=0.9274
+pbswgs=1.4338
+saref=1.44e-06
+sbref=1.44e-06
+wlod={0+sky130_fd_pr__pfet_01v8_lvt__wlod_diff}
+kvth0={0+sky130_fd_pr__pfet_01v8_lvt__kvth0_diff}
+lkvth0={0+sky130_fd_pr__pfet_01v8_lvt__lkvth0_diff}
+wkvth0={0+sky130_fd_pr__pfet_01v8_lvt__wkvth0_diff}
+pkvth0=0
+llodvth=0
+wlodvth=1
+stk2=0
+lodk2=1
+lodeta0=1
+ku0={0+sky130_fd_pr__pfet_01v8_lvt__ku0_diff}
+lku0={0+sky130_fd_pr__pfet_01v8_lvt__lku0_diff}
+wku0={0+sky130_fd_pr__pfet_01v8_lvt__wku0_diff}
+pku0=0
+llodku0=0
+wlodku0=1
+kvsat={0+sky130_fd_pr__pfet_01v8_lvt__kvsat_diff}
+steta0=0
+tku0=0
+ucste=0
+lucste=0
+wucste=0
+pucste=0

.model sky130_fd_pr__pfet_01v8_lvt__model.1 pmos
+lmin=4e-06
+lmax=8e-06
+wmin=3e-06
+wmax=5e-06
+level=54
+tnom=-196.15
+version=4.82
+toxm=4.23e-09
+xj=1.5e-07
+lln=1
+lwn=1
+wln=1
+wwn=1
+lint=2.8e-09
+ll=0
+lw=0
+lwl=0
+wint=7.476e-09
+wl=0
+ww=0
+wwl=0
+xl=0
+xw=0
+mobmod=0
+binunit=2
+dwg=-7.916e-09
+dwb=0
+igcmod=0
+igbmod=0
+rgatemod=0
+rbodymod=1
+trnqsmod=0
+acnqsmod=0
+fnoimod=1
+tnoimod=1
+permod=1
+geomod=0
+rdsmod=0
+tempmod=0
+lintnoi=0
+vfbsdoff=0
+lambda=0
+vtl=0
+lc=5e-09
+xn=3
+rnoia=0.69
+rnoib=0.34
+tnoia=2.5e+07
+tnoib=0
+epsrox=3.9
+toxe={4.23e-09+MC_MM_SWITCH*my_gauss*(4.23e-09*(0.003689/sqrt(l*w*m)))}
+dtox=0
+ndep=1.7e+17
+nsd=1e+20
+rshg=0.1
+rsh=1
+vth0={(-4.387610425e-01+MC_MM_SWITCH*my_gauss*(0.01389/sqrt(l*w*m)))*2.63072}
+lvth0=-4.95899e-08
+wvth0=-4.31354e-08
+pvth0=5.88106e-13
+k1=0.64774
+k2=-0.0368743
+lk2=-5.8921e-08
+wk2=-4.19223e-08
+pk2=2.72023e-13
+k3=3.39
+dvt0={2.4422*1}
+dvt1={0.16136*1}
+dvt2=0.026237
+dvt0w=0.5
+dvt1w=1.9281e+06
+dvt2w=-0.032
+w0=1e-08
+k3b=1
+phin=0
+lpe0=0
+lpeb=0
+vbm=-3
+dvtp0=0
+dvtp1=0
+vsat={123760.0*5999.62}
+ua={-3.152665434e-09*1}
+lua=3.57454e-16
+wua=9.66927e-16
+pua=-1.78192e-21
+ub={3.070076680e-18*1}
+wub=-5.20821e-25
+uc={3.055610254e-11*1}
+wuc=9.06675e-17
+rdsw={484.7*32.2943}
+prwb=0.1
+prwg={0.052*1}
+wr=1
+u0={1.895206273e-03*15.6882}
+lu0=2.0277e-09
+wu0=2.92999e-09
+pu0=-9.26987e-15
+a0=1.82346
+la0=-4.51756e-07
+wa0=-3.66055e-07
+pa0=2.42116e-12
+keta=-0.01258
+a1=0
+a2=0.467037
+ags=0.320883
+lags=4.21523e-07
+wags=-3.43156e-09
+pags=-3.48426e-13
+b0=0
+b1=2.1073e-24
+eu=1.67
+rdswmin=0
+rdw={1e-12*1}
+rdwmin=0
+rsw={1e-12*1}
+rswmin=0
+voff={-0.1819+MC_MM_SWITCH*my_gauss*(0/sqrt(l*w*m))}
+nfactor={(2.5373+MC_MM_SWITCH*my_gauss*(0/sqrt(l*w*m)))*10.5543}
+up=0
+ud=0
+lp=1
+tvfbsdoff=0
+tvoff=0
+cit=-6.39311e-11
+cdsc=2.8125e-07
+cdscb=0.0001
+cdscd=1e-10
+eta0={0.2*1}
+etab=-0.00025
+dsub={1.0*1}
+voffl=0
+minv=0
+pclm={0.030097*1}
+pdiblc1=0
+pdiblc2=-0.00149752
+lpdiblc2=1.79185e-08
+wpdiblc2=8.24231e-09
+ppdiblc2=-3.00076e-14
+pdiblcb=-0.025
+drout=0.43496
+pscbe1=8e+08
+pscbe2=8.6797e-09
+pvag={1e-12*1}
+delta={1.181842103e-02*1}
+ldelta=1.16179e-08
+wdelta=5.87823e-09
+pdelta=1.29487e-13
+alpha0=5.04495e-13
+alpha1=-4.05837e-18
+beta0=6.20165
+fprout=0
+pdits=0
+pditsl=0
+pditsd=0
+agidl=0
+bgidl=2.3e+09
+cgidl=0.5
+egidl=0.8
+aigbacc=0.43
+bigbacc=0.054
+cigbacc=0.075
+nigbacc=1
+aigbinv=0.35
+bigbinv=0.03
+cigbinv=0.006
+eigbinv=1.1
+nigbinv=3
+aigc=0.43
+bigc=0.054
+cigc=0.075
+nigc=1
+aigsd=0.43
+bigsd=0.054
+cigsd=0.075
+dlcig=0
+poxedge=1
+pigcd=1
+ntox=1
+toxref=4.23e-09
+kt1=0
+lkt1=0
+kt2=0
+at=0
+lat=0
+wat=0
+pat=0
+ute=0
+lute=0
+wute=0
+pute=0
+ua1=0
+lua1=0
+ub1=0
+lub1=0
+wub1=0
+pub1=0
+uc1=0
+kt1l=0
+prt=0
+xrcrg1=12
+xrcrg2=1
+rbpb=50
+rbpd=50
+rbps=50
+rbdb=50
+rbsb=50
+gbmin=1e-12
+noia=3e+41
+noib=0
+noic=0
+em=4.1e+07
+af=1
+ef=0.88
+kf=0
+ntnoi=1
+dmcg=0
+dmcgt=0
+dmdg=0
+xgw=0
+xgl=0
+ngcon=1
+diomod=1
+njs=1.3632
+jss=2.1483e-05
+jsws=1.4472e-10
+xtis=0
+bvs=12.69
+xjbvs=1
+ijthsrev=0.1
+ijthsfwd=0.1
+tpb=0.001671
+tpbsw=0.001246
+tpbswg=0
+tcj=0.0012407
+tcjsw=0.00037357
+tcjswg=2e-12
+cgdo=2e-11
+cgso=2e-11
+cgbo=1e-13
+capmod=2
+xpart=0
+cgsl=0
+cgdl=0
+cf=0
+clc=7e-08
+cle=0.492
+dlc=-1.2e-08
+dwc=0
+vfbcv=-1
+acde=0.44
+moin=8.7
+noff=2.6123
+voffcv=0.112
+ngate=1e+23
+lwc=0
+llc=0
+lwlc=0
+wlc=0
+wwc=0
+wwlc=0
+ckappas=0.6
+cjs=0.000765357
+mjs=0.3362
+pbs=0.6587
+cjsws=9.16024e-11
+mjsws=0.2659
+pbsws=0.7418
+cjswgs=2.39155e-10
+mjswgs=0.9274
+pbswgs=1.4338
+saref=3e-06
+sbref=3e-06
+wlod={0+sky130_fd_pr__pfet_01v8_lvt__wlod_diff}
+kvth0={0+sky130_fd_pr__pfet_01v8_lvt__kvth0_diff}
+lkvth0={0+sky130_fd_pr__pfet_01v8_lvt__lkvth0_diff}
+wkvth0={0+sky130_fd_pr__pfet_01v8_lvt__wkvth0_diff}
+pkvth0=0
+llodvth=0
+wlodvth=1
+stk2=0
+lodk2=1
+lodeta0=1
+ku0={0+sky130_fd_pr__pfet_01v8_lvt__ku0_diff}
+lku0={0+sky130_fd_pr__pfet_01v8_lvt__lku0_diff}
+wku0={0+sky130_fd_pr__pfet_01v8_lvt__wku0_diff}
+pku0=0
+llodku0=0
+wlodku0=1
+kvsat={0+sky130_fd_pr__pfet_01v8_lvt__kvsat_diff}
+steta0=0
+tku0=0
+wkt1=0
+pkt1=0
+lkt2=0
+wkt2=0
+pkt2=0
+wua1=0
+pua1=0
+luc1=0
+wuc1=0
+puc1=0
+ucste=0
+lucste=0
+wucste=0
+pucste=0
* DC IV MOS Parameters
* BSIM4 - Model Selectors
* BSIM4 - Process Parameters
*(mismatch parameter 0)
* Threshold Voltage Parameters
*(mismatch parameter 0)
* NEW BSIM4 Parameters for Level 54
* Mobility Parameters
* BSIM4 - Mobility Parameters
* Subthreshold Current Parameters
*(mismatch parameter 0)
*(mismatch parameter 0)
* BSIM4 - Sub-threshold parameters
* Rout Parameters
* BSIM4 - Rout Parameters
* BSIM4 - Gate Induced Drain Leakage Model Parameters
* BSIM4 - Gate Leakage Current Parameters
* Temperature Effects Parameters
* BSIM4 - High Speed RF Model Parameters
* BSIM4 - Flicker and Thermal Noise Parameters
* BSIM4 - Layout Dependent Parasitic Model Parameters
* Diode DC IV Parameters
* BSIM4 - Diode DC IV parameters
* Diode and FET Capacitance Parameters
* BSIM4 - FET and Diode capacitance parameters
* Stress Parameters

.model sky130_fd_pr__pfet_01v8_lvt__model.2 pmos
+lmin=4e-06
+lmax=8e-06
+wmin=5e-06
+wmax=7e-06
+level=54
+tnom=-196.15
+version=4.82
+toxm=4.23e-09
+xj=1.5e-07
+lln=1
+lwn=1
+wln=1
+wwn=1
+lint=2.8e-09
+ll=0
+lw=0
+lwl=0
+wint=7.476e-09
+wl=0
+ww=0
+wwl=0
+xl=0
+xw=0
+mobmod=0
+binunit=2
+dwg=-7.916e-09
+dwb=0
+igcmod=0
+igbmod=0
+rgatemod=0
+rbodymod=1
+trnqsmod=0
+acnqsmod=0
+fnoimod=1
*+tnoimod=1
+permod=1
+geomod=0
+rdsmod=0
+tempmod=0
+lintnoi=0
+vfbsdoff=0
+lambda=0
+vtl=0
+lc=5e-09
+xn=3
+rnoia=0.69
+rnoib=0.34
+tnoia=2.5e+07
+tnoib=0
+epsrox=3.9
+toxe={4.23e-09+MC_MM_SWITCH*my_gauss*(4.23e-09*(0.003689/sqrt(l*w*m)))}
+dtox=0
+ndep=1.7e+17
+nsd=1e+20
+rshg=0.1
+rsh=1
+vth0={(-4.981316602e-01+MC_MM_SWITCH*my_gauss*(0.01389/sqrt(l*w*m)))*2.38937}
+lvth0=9.27526e-08
+wvth0=2.5283e-07
+pvth0=-1.21478e-13
+k1=0.64774
+k2=-0.0580572
+lk2=4.19561e-08
+wk2=6.36757e-08
+pk2=-2.30854e-13
+k3=3.39
+dvt0={2.4422*1}
+dvt1={0.16136*1}
+dvt2=0.026237
+dvt0w=0.5
+dvt1w=1.9281e+06
+dvt2w=-0.032
+w0=1e-08
+k3b=1
+phin=0
+lpe0=0
+lpeb=0
+vbm=-3
+dvtp0=0
+dvtp1=0
+vsat={123760.0*5973.51}
+ua={-3.327222541e-09*1}
+lua=1.64222e-15
+wua=1.8371e-15
+pua=-8.18656e-21
+ub={3.543176576e-18*1}
+lub=-2.48703e-24
+wub=-2.87925e-24
+pub=1.2398e-29
+uc={1.049460290e-11*1}
+luc=3.22785e-16
+wuc=1.90675e-16
+puc=-1.6091e-21
+rdsw={484.7*21.2644}
+prwb=0.1
+prwg={0.052*1}
+wr=1
+u0={2.370302029e-03*15.7457}
+lu0=1.8586e-09
+wu0=5.61613e-10
+pu0=-8.42689e-15
+a0=2.06924
+la0=-2.57885e-06
+wa0=-1.59129e-06
+pa0=1.30248e-11
+keta=-0.01258
+a1=0
+a2=0.467037
+ags=0.489046
+lags=-4.15895e-07
+wags=-8.41731e-07
+pags=3.82614e-12
+b0=0
+b1=2.1073e-24
+eu=1.67
+rdswmin=0
+rdw={1e-12*1}
+rdwmin=0
+rsw={1e-12*1}
+rswmin=0
+voff={-0.1819+MC_MM_SWITCH*my_gauss*(0/sqrt(l*w*m))}
+nfactor={(2.5373+MC_MM_SWITCH*my_gauss*(0/sqrt(l*w*m)))*15.317}
+up=0
+ud=0
+lp=1
+tvfbsdoff=0
+tvoff=0
+cit=-6.39311e-11
+cdsc=2.8125e-07
+cdscb=0.0001
+cdscd=1e-10
+eta0={0.2*1}
+etab=-0.00025
+dsub={1.0*1}
+voffl=0
+minv=0
+pclm={0.030097*1}
+pdiblc1=0
+pdiblc2=-0.000127018
+lpdiblc2=1.9809e-08
+wpdiblc2=1.41029e-09
+ppdiblc2=-3.94317e-14
+pdiblcb=-0.025
+drout=0.43496
+pscbe1=8e+08
+pscbe2=8.6797e-09
+pvag={1e-12*1}
+delta={-1.193099316e-02*1}
+ldelta=1.23245e-07
+wdelta=1.2427e-07
+pdelta=-4.2698e-13
+alpha0=5.04495e-13
+alpha1=-4.05837e-18
+beta0=6.20165
+fprout=0
+pdits=0
+pditsl=0
+pditsd=0
+agidl=0
+bgidl=2.3e+09
+cgidl=0.5
+egidl=0.8
+aigbacc=0.43
+bigbacc=0.054
+cigbacc=0.075
+nigbacc=1
+aigbinv=0.35
+bigbinv=0.03
+cigbinv=0.006
+eigbinv=1.1
+nigbinv=3
+aigc=0.43
+bigc=0.054
+cigc=0.075
+nigc=1
+aigsd=0.43
+bigsd=0.054
+cigsd=0.075
+dlcig=0
+poxedge=1
+pigcd=1
+ntox=1
+toxref=4.23e-09
+kt1=0
+lkt1=0
+kt2=0
+at=0
+lat=0
+ute=0
+lute=0
+ua1=0
+lua1=0
+ub1=0
+lub1=0
+uc1=0
+kt1l=0
+prt=0
+xrcrg1=12
+xrcrg2=1
+rbpb=50
+rbpd=50
+rbps=50
+rbdb=50
+rbsb=50
+gbmin=1e-12
+noia=3e+41
+noib=0
+noic=0
+em=4.1e+07
+af=1
+ef=0.88
+kf=0
+ntnoi=1
+dmcg=0
+dmcgt=0
+dmdg=0
+xgw=0
+xgl=0
+ngcon=1
+diomod=1
+njs=1.3632
+jss=2.1483e-05
+jsws=1.4472e-10
+xtis=0
+bvs=12.69
+xjbvs=1
+ijthsrev=0.1
+ijthsfwd=0.1
+tpb=0.001671
+tpbsw=0.001246
+tpbswg=0
+tcj=0.0012407
+tcjsw=0.00037357
+tcjswg=2e-12
+cgdo=2e-11
+cgso=2e-11
+cgbo=1e-13
+capmod=2
+xpart=0
+cgsl=0
+cgdl=0
+cf=0
+clc=7e-08
+cle=0.492
+dlc=-1.2e-08
+dwc=0
+vfbcv=-1
+acde=0.44
+moin=8.7
+noff=2.6123
+voffcv=0.112
+ngate=1e+23
+lwc=0
+llc=0
+lwlc=0
+wlc=0
+wwc=0
+wwlc=0
+ckappas=0.6
+cjs=0.000765357
+mjs=0.3362
+pbs=0.6587
+cjsws=9.16024e-11
+mjsws=0.2659
+pbsws=0.7418
+cjswgs=2.39155e-10
+mjswgs=0.9274
+pbswgs=1.4338
+saref=3e-06
+sbref=3e-06
+wlod={0+sky130_fd_pr__pfet_01v8_lvt__wlod_diff}
+kvth0={0+sky130_fd_pr__pfet_01v8_lvt__kvth0_diff}
+lkvth0={0+sky130_fd_pr__pfet_01v8_lvt__lkvth0_diff}
+wkvth0={0+sky130_fd_pr__pfet_01v8_lvt__wkvth0_diff}
+pkvth0=0
+llodvth=0
+wlodvth=1
+stk2=0
+lodk2=1
+lodeta0=1
+ku0={0+sky130_fd_pr__pfet_01v8_lvt__ku0_diff}
+lku0={0+sky130_fd_pr__pfet_01v8_lvt__lku0_diff}
+wku0={0+sky130_fd_pr__pfet_01v8_lvt__wku0_diff}
+pku0=0
+llodku0=0
+wlodku0=1
+kvsat={0+sky130_fd_pr__pfet_01v8_lvt__kvsat_diff}
+steta0=0
+tku0=0
+wat=0
+pat=0
+wkt1=0
+pkt1=0
+lkt2=0
+wkt2=0
+pkt2=0
+wute=0
+pute=0
+wua1=0
+pua1=0
+wub1=0
+pub1=0
+luc1=0
+wuc1=0
+puc1=0
+ucste=0
+lucste=0
+wucste=0
+pucste=0
* DC IV MOS Parameters
* BSIM4 - Model Selectors
* BSIM4 - Process Parameters
*(mismatch parameter 0)
* Threshold Voltage Parameters
*(mismatch parameter 0)
* NEW BSIM4 Parameters for Level 54
* Mobility Parameters
* BSIM4 - Mobility Parameters
* Subthreshold Current Parameters
*(mismatch parameter 0)
*(mismatch parameter 0)
* BSIM4 - Sub-threshold parameters
* Rout Parameters
* BSIM4 - Rout Parameters
* BSIM4 - Gate Induced Drain Leakage Model Parameters
* BSIM4 - Gate Leakage Current Parameters
* Temperature Effects Parameters
* BSIM4 - High Speed RF Model Parameters
* BSIM4 - Flicker and Thermal Noise Parameters
* BSIM4 - Layout Dependent Parasitic Model Parameters
* Diode DC IV Parameters
* BSIM4 - Diode DC IV parameters
* Diode and FET Capacitance Parameters
* BSIM4 - FET and Diode capacitance parameters
* Stress Parameters

.model sky130_fd_pr__pfet_01v8_lvt__model.3 pmos
+lmin=3.5e-07
+lmax=5e-07
+wmin=1e-06
+wmax=3e-06
+level=54
+tnom=-196.15
+version=4.82
+toxm=4.23e-09
+xj=1.5e-07
+lln=1
+lwn=1
+wln=1
+wwn=1
+lint=2.8e-09
+ll=0
+lw=0
+lwl=0
+wint=7.476e-09
+wl=0
+ww=0
+wwl=0
+xl=0
+xw=0
+mobmod=0
+binunit=2
+dwg=-7.916e-09
+dwb=0
+igcmod=0
+igbmod=0
+rgatemod=0
+rbodymod=1
+trnqsmod=0
+acnqsmod=0
+fnoimod=1
+tnoimod=1
+permod=1
+geomod=0
+rdsmod=0
+tempmod=0
+lintnoi=0
+vfbsdoff=0
+lambda=0
+vtl=0
+lc=5e-09
+xn=3
+rnoia=0.69
+rnoib=0.34
+tnoia=2.5e+07
+tnoib=0
+epsrox=3.9
+toxe={4.23e-09+MC_MM_SWITCH*my_gauss*(4.23e-09*(0.02389/sqrt(l*w*m)))}
+dtox=0
+ndep=1.7e+17
+nsd=1e+20
+rshg=0.1
+rsh=1
+vth0={(-5.458335523e-01+MC_MM_SWITCH*my_gauss*(0.01389/sqrt(l*w*m)))*2.08113}
+lvth0=4.78763e-08
+wvth0=2.2721e-07
+pvth0=-6.87602e-14
+k1=0.64774
+k2=-0.0928809
+lk2=1.88911e-08
+wk2=3.47563e-08
+pk2=-8.52373e-15
+k3=3.39
+dvt0={2.4422*1}
+dvt1={0.16136*1}
+dvt2=0.026237
+dvt0w=0.5
+dvt1w=1.9281e+06
+dvt2w=-0.032
+w0=1e-08
+k3b=1
+phin=0
+lpe0=0
+lpeb=0
+vbm=-3
+dvtp0=0
+dvtp1=0
+vsat={1.027510387e+05*9999.92}
+lvsat=0.0103597
+wvsat=0.00611451
+pvsat=-1.23405e-08
+ua={-2.321180996e-09*1}
+lua=-2.14828e-16
+wua=-5.05604e-16
+pua=1.6689e-22
+ub={2.016844244e-18*1}
+lub=4.25324e-25
+wub=5.06872e-25
+pub=-1.7006e-31
+uc={1.174942768e-10*1}
+luc=-2.41394e-17
+wuc=-5.97513e-17
+puc=2.37784e-23
+rdsw={484.7*1.11407e-05}
+prwb=0.1
+prwg={0.052*1}
+wr=1
+u0={3.487838784e-03*3.41512}
+lu0=-4.9634e-11
+wu0=-1.34533e-09
+pu0=2.93897e-16
+a0=2.03763
+la0=-1.3103e-07
+wa0=-8.6185e-07
+pa0=1.29071e-13
+keta=-0.0117262
+lketa=-4.22109e-10
+wketa=-2.54858e-09
+pketa=1.26002e-15
+a1=0
+a2=0.467037
+ags=0.330004
+wags=-7.1952e-08
+b0=-5.42344e-06
+lb0=1.89759e-12
+wb0=5.38139e-12
+pb0=-1.94219e-18
+b1=5.12746e-08
+lb1=-5.25763e-14
+wb1=-1.53057e-13
+pb1=1.56943e-19
+eu=1.67
+rdswmin=0
+rdw={1e-12*1}
+rdwmin=0
+rsw={1e-12*1}
+rswmin=0
+voff={-0.1819+MC_MM_SWITCH*my_gauss*(0/sqrt(l*w*m))}
+nfactor={(4.667430253e+00+MC_MM_SWITCH*my_gauss*(0/sqrt(l*w*m)))*13.5087}
+wnfactor=-2.09828e-06
+up=0
+ud=0
+lp=1
+tvfbsdoff=0
+tvoff=0
+cit=-6.39311e-11
+cdsc=2.8125e-07
+cdscb=0.0001
+cdscd=1e-10
+eta0={0.2*1}
+etab=-0.00025
+dsub={1.0*1}
+voffl=0
+minv=0
+pclm={0.030097*1}
+pdiblc1=0
+pdiblc2=-0.0966654
+lpdiblc2=6.78966e-08
+wpdiblc2=4.76568e-08
+ppdiblc2=-1.92374e-14
+pdiblcb=-0.025
+drout=0.43496
+pscbe1=8e+08
+pscbe2=8.6797e-09
+pvag={1e-12*1}
+delta={-1.535133613e-02*1}
+ldelta=4.15317e-08
+wdelta=9.8404e-08
+pdelta=-5.19727e-14
+alpha0=5.04495e-13
+alpha1=-4.05837e-18
+beta0=6.20165
+fprout=0
+pdits=0
+pditsl=0
+pditsd=0
+agidl=0
+bgidl=2.3e+09
+cgidl=0.5
+egidl=0.8
+aigbacc=0.43
+bigbacc=0.054
+cigbacc=0.075
+nigbacc=1
+aigbinv=0.35
+bigbinv=0.03
+cigbinv=0.006
+eigbinv=1.1
+nigbinv=3
+aigc=0.43
+bigc=0.054
+cigc=0.075
+nigc=1
+aigsd=0.43
+bigsd=0.054
+cigsd=0.075
+dlcig=0
+poxedge=1
+pigcd=1
+ntox=1
+toxref=4.23e-09
+kt1=0
+lkt1=0
+wkt1=0
+pkt1=0
+kt2=0
+lkt2=0
+wkt2=0
+pkt2=0
+at=0
+lat=0
+wat=0
+pat=0
+ute=0
+lute=0
+wute=0
+pute=0
+ua1=0
+lua1=0
+wua1=0
+pua1=0
+ub1=0
+lub1=0
+wub1=0
+pub1=0
+uc1=0
+luc1=0
+wuc1=0
+puc1=0
+kt1l=0
+prt=0
+xrcrg1=12
+xrcrg2=1
+rbpb=50
+rbpd=50
+rbps=50
+rbdb=50
+rbsb=50
+gbmin=1e-12
+noia=3e+41
+noib=0
+noic=0
+em=4.1e+07
+af=1
+ef=0.88
+kf=0
+ntnoi=1
+dmcg=0
+dmcgt=0
+dmdg=0
+xgw=0
+xgl=0
+ngcon=1
+diomod=1
+njs=1.3632
+jss=2.1483e-05
+jsws=1.4472e-10
+xtis=0
+bvs=12.69
+xjbvs=1
+ijthsrev=0.1
+ijthsfwd=0.1
+tpb=0.001671
+tpbsw=0.001246
+tpbswg=0
+tcj=0.0012407
+tcjsw=0.00037357
+tcjswg=2e-12
+cgdo=2e-11
+cgso=2e-11
+cgbo=1e-13
+capmod=2
+xpart=0
+cgsl=0
+cgdl=0
+cf=0
+clc=7e-08
+cle=0.492
+dlc=-1.2e-08
+dwc=0
+vfbcv=-1
+acde=0.44
+moin=8.7
+noff=2.6123
+voffcv=0.112
+ngate=1e+23
+lwc=0
+llc=0
+lwlc=0
+wlc=0
+wwc=0
+wwlc=0
+ckappas=0.6
+cjs=0.000765357
+mjs=0.3362
+pbs=0.6587
+cjsws=9.16024e-11
+mjsws=0.2659
+pbsws=0.7418
+cjswgs=2.39155e-10
+mjswgs=0.9274
+pbswgs=1.4338
+saref=1.44e-06
+sbref=1.44e-06
+wlod={0+sky130_fd_pr__pfet_01v8_lvt__wlod_diff}
+kvth0={0+sky130_fd_pr__pfet_01v8_lvt__kvth0_diff}
+lkvth0={0+sky130_fd_pr__pfet_01v8_lvt__lkvth0_diff}
+wkvth0={0+sky130_fd_pr__pfet_01v8_lvt__wkvth0_diff}
+pkvth0=0
+llodvth=0
+wlodvth=1
+stk2=0
+lodk2=1
+lodeta0=1
+ku0={0+sky130_fd_pr__pfet_01v8_lvt__ku0_diff}
+lku0={0+sky130_fd_pr__pfet_01v8_lvt__lku0_diff}
+wku0={0+sky130_fd_pr__pfet_01v8_lvt__wku0_diff}
+pku0=0
+llodku0=0
+wlodku0=1
+kvsat={0+sky130_fd_pr__pfet_01v8_lvt__kvsat_diff}
+steta0=0
+tku0=0
+ucste=0
+lucste=0
+wucste=0
+pucste=0
* DC IV MOS Parameters
* BSIM4 - Model Selectors
* BSIM4 - Process Parameters
*(mismatch parameter 0)
* Threshold Voltage Parameters
*(mismatch parameter 0)
* NEW BSIM4 Parameters for Level 54
* Mobility Parameters
* BSIM4 - Mobility Parameters
* Subthreshold Current Parameters
*(mismatch parameter 0)
*(mismatch parameter 0)
* BSIM4 - Sub-threshold parameters
* Rout Parameters
* BSIM4 - Rout Parameters
* BSIM4 - Gate Induced Drain Leakage Model Parameters
* BSIM4 - Gate Leakage Current Parameters
* Temperature Effects Parameters
* BSIM4 - High Speed RF Model Parameters
* BSIM4 - Flicker and Thermal Noise Parameters
* BSIM4 - Layout Dependent Parasitic Model Parameters
* Diode DC IV Parameters
* BSIM4 - Diode DC IV parameters
* Diode and FET Capacitance Parameters
* BSIM4 - FET and Diode capacitance parameters
* Stress Parameters

.model sky130_fd_pr__pfet_01v8_lvt__model.4 pmos
+lmin=5e-07
+lmax=1e-06
+wmin=5.5e-07
+wmax=1e-06
+level=54
+tnom=-196.15
+version=4.82
+toxm=4.23e-09
+xj=1.5e-07
+lln=1
+lwn=1
+wln=1
+wwn=1
+lint=2.8e-09
+ll=0
+lw=0
+lwl=0
+wint=7.476e-09
+wl=0
+ww=0
+wwl=0
+xl=0
+xw=0
+mobmod=0
+binunit=2
+dwg=-7.916e-09
+dwb=0
+igcmod=0
+igbmod=0
+rgatemod=0
+rbodymod=1
+trnqsmod=0
+acnqsmod=0
+fnoimod=1
+tnoimod=1
+permod=1
+geomod=0
+rdsmod=0
+tempmod=0
+lintnoi=0
+vfbsdoff=0
+lambda=0
+vtl=0
+lc=5e-09
+xn=3
+rnoia=0.69
+rnoib=0.34
+tnoia=2.5e+07
+tnoib=0
+epsrox=3.9
+toxe={4.23e-09+MC_MM_SWITCH*my_gauss*(4.23e-09*(0.01689/sqrt(l*w*m)))}
+dtox=0
+ndep=1.7e+17
+nsd=1e+20
+rshg=0.1
+rsh=1
+vth0={(-4.019187402e-01+MC_MM_SWITCH*my_gauss*(0.009789/sqrt(l*w*m)))*2.7}
+lvth0=3.83662e-08
+wvth0=3.01132e-08
+pvth0=-3.20354e-14
+k1=0.64774
+k2=-0.0292057
+lk2=-4.7034e-09
+wk2=-2.83226e-09
+pk2=2.29148e-15
+k3=3.39
+dvt0={2.4422*1}
+dvt1={0.16136*1}
+dvt2=0.026237
+dvt0w=0.5
+dvt1w=1.9281e+06
+dvt2w=-0.032
+w0=1e-08
+k3b=1
+phin=0
+lpe0=0
+lpeb=0
+vbm=-3
+dvtp0=0
+dvtp1=0
+vsat={1.863063691e+05*7999.69}
+lvsat=-0.0263855
+wvsat=-0.0429227
+pvsat=7.40719e-09
+ua={-3.101914627e-09*1}
+lua=7.47732e-17
+wua=2.51351e-16
+pua=-1.12398e-22
+ub={3.331728366e-18*1}
+lub=-1.64745e-25
+wub=-4.41629e-25
+pub=2.39766e-31
+uc={6.494258832e-11*1}
+luc=-1.03548e-17
+wuc=7.19736e-18
+puc=2.69363e-24
+rdsw={484.7*15}
+prwb=0.1
+prwg={0.052*1}
+wr=1
+u0={2.463957687e-03*24.9999}
+lu0=-1.01256e-10
+wu0=2.49468e-10
+pu0=5.4917e-17
+a0=1.76649
+la0=-2.98513e-07
+wa0=-1.57269e-07
+pa0=7.77536e-14
+keta=-0.0134777
+wketa=8.84269e-10
+a1=0
+a2=0.467037
+ags=0.799218
+lags=-4.10961e-07
+wags=-1.92019e-07
+pags=2.35666e-13
+b0=8.7529e-08
+lb0=-5.71317e-14
+wb0=2.11162e-14
+pb0=-5.0458e-20
+b1=-5.70131e-07
+lb1=1.60806e-13
+wb1=4.52702e-13
+pb1=-5.01068e-20
+eu=1.67
+rdswmin=0
+rdw={1e-12*1}
+rdwmin=0
+rsw={1e-12*1}
+rswmin=0
+voff={-0.1819+MC_MM_SWITCH*my_gauss*(0/sqrt(l*w*m))}
+nfactor={(2.5373+MC_MM_SWITCH*my_gauss*(0/sqrt(l*w*m)))*27.8475}
+up=0
+ud=0
+lp=1
+tvfbsdoff=0
+tvoff=0
+cit=-6.39311e-11
+cdsc=2.8125e-07
+cdscb=0.0001
+cdscd=1e-10
+eta0={0.2*1}
+etab=-0.00025
+dsub={1.0*1}
+voffl=0
+minv=0
+pclm={0.030097*1}
+pdiblc1=0
+pdiblc2=0.0130037
+lpdiblc2=1.87513e-09
+wpdiblc2=-2.62583e-08
+ppdiblc2=2.89309e-14
+pdiblcb=-0.025
+drout=0.43496
+pscbe1=8e+08
+pscbe2=8.6797e-09
+pvag={1e-12*1}
+delta={3.609779515e-02*1}
+ldelta=2.8798e-08
+wdelta=-4.18345e-09
+pdelta=-1.37664e-14
+alpha0=5.04495e-13
+alpha1=-4.05837e-18
+beta0=6.20165
+fprout=0
+pdits=0
+pditsl=0
+pditsd=0
+agidl=0
+bgidl=2.3e+09
+cgidl=0.5
+egidl=0.8
+aigbacc=0.43
+bigbacc=0.054
+cigbacc=0.075
+nigbacc=1
+aigbinv=0.35
+bigbinv=0.03
+cigbinv=0.006
+eigbinv=1.1
+nigbinv=3
+aigc=0.43
+bigc=0.054
+cigc=0.075
+nigc=1
+aigsd=0.43
+bigsd=0.054
+cigsd=0.075
+dlcig=0
+poxedge=1
+pigcd=1
+ntox=1
+toxref=4.23e-09
+kt1=0
+lkt1=0
+wkt1=0
+pkt1=0
+kt2=0
+lkt2=0
+wkt2=0
+pkt2=0
+at=0
+lat=0
+wat=0
+pat=0
+ute=0
+lute=0
+wute=0
+pute=0
+ua1=0
+lua1=0
+wua1=0
+pua1=0
+ub1=0
+lub1=0
+wub1=0
+pub1=0
+uc1=0
+luc1=0
+wuc1=0
+puc1=0
+kt1l=0
+prt=0
+xrcrg1=12
+xrcrg2=1
+rbpb=50
+rbpd=50
+rbps=50
+rbdb=50
+rbsb=50
+gbmin=1e-12
+noia=3e+41
+noib=0
+noic=0
+em=4.1e+07
+af=1
+ef=0.88
+kf=0
+ntnoi=1
+dmcg=0
+dmcgt=0
+dmdg=0
+xgw=0
+xgl=0
+ngcon=1
+diomod=1
+njs=1.3632
+jss=2.1483e-05
+jsws=1.4472e-10
+xtis=0
+bvs=12.69
+xjbvs=1
+ijthsrev=0.1
+ijthsfwd=0.1
+tpb=0.001671
+tpbsw=0.001246
+tpbswg=0
+tcj=0.0012407
+tcjsw=0.00037357
+tcjswg=2e-12
+cgdo=2e-11
+cgso=2e-11
+cgbo=1e-13
+capmod=2
+xpart=0
+cgsl=0
+cgdl=0
+cf=0
+clc=7e-08
+cle=0.492
+dlc=-1.2e-08
+dwc=0
+vfbcv=-1
+acde=0.44
+moin=8.7
+noff=2.6123
+voffcv=0.112
+ngate=1e+23
+lwc=0
+llc=0
+lwlc=0
+wlc=0
+wwc=0
+wwlc=0
+ckappas=0.6
+cjs=0.000765357
+mjs=0.3362
+pbs=0.6587
+cjsws=9.16024e-11
+mjsws=0.2659
+pbsws=0.7418
+cjswgs=2.39155e-10
+mjswgs=0.9274
+pbswgs=1.4338
+saref=1.74e-06
+sbref=1.74e-06
+wlod={0+sky130_fd_pr__pfet_01v8_lvt__wlod_diff}
+kvth0={0+sky130_fd_pr__pfet_01v8_lvt__kvth0_diff}
+lkvth0={0+sky130_fd_pr__pfet_01v8_lvt__lkvth0_diff}
+wkvth0={0+sky130_fd_pr__pfet_01v8_lvt__wkvth0_diff}
+pkvth0=0
+llodvth=0
+wlodvth=1
+stk2=0
+lodk2=1
+lodeta0=1
+ku0={0+sky130_fd_pr__pfet_01v8_lvt__ku0_diff}
+lku0={0+sky130_fd_pr__pfet_01v8_lvt__lku0_diff}
+wku0={0+sky130_fd_pr__pfet_01v8_lvt__wku0_diff}
+pku0=0
+llodku0=0
+wlodku0=1
+kvsat={0+sky130_fd_pr__pfet_01v8_lvt__kvsat_diff}
+steta0=0
+tku0=0
+ucste=0
+lucste=0
+wucste=0
+pucste=0
* DC IV MOS Parameters
* BSIM4 - Model Selectors
* BSIM4 - Process Parameters
*(mismatch parameter 0)
* Threshold Voltage Parameters
*(mismatch parameter 0)
* NEW BSIM4 Parameters for Level 54
* Mobility Parameters
* BSIM4 - Mobility Parameters
* Subthreshold Current Parameters
*(mismatch parameter 0)
*(mismatch parameter 0)
* BSIM4 - Sub-threshold parameters
* Rout Parameters
* BSIM4 - Rout Parameters
* BSIM4 - Gate Induced Drain Leakage Model Parameters
* BSIM4 - Gate Leakage Current Parameters
* Temperature Effects Parameters
* BSIM4 - High Speed RF Model Parameters
* BSIM4 - Flicker and Thermal Noise Parameters
* BSIM4 - Layout Dependent Parasitic Model Parameters
* Diode DC IV Parameters
* BSIM4 - Diode DC IV parameters
* Diode and FET Capacitance Parameters
* BSIM4 - FET and Diode capacitance parameters
* Stress Parameters

.model sky130_fd_pr__pfet_01v8_lvt__model.5 pmos
+lmin=3.5e-07
+lmax=5e-07
+wmin=5.5e-07
+wmax=1e-06
+level=54
+tnom=-196.15
+version=4.82
+toxm=4.23e-09
+xj=1.5e-07
+lln=1
+lwn=1
+wln=1
+wwn=1
+lint=2.8e-09
+ll=0
+lw=0
+lwl=0
+wint=7.476e-09
+wl=0
+ww=0
+wwl=0
+xl=0
+xw=0
+mobmod=0
+binunit=2
+dwg=-7.916e-09
+dwb=0
+igcmod=0
+igbmod=0
+rgatemod=0
+rbodymod=1
+trnqsmod=0
+acnqsmod=0
+fnoimod=1
+tnoimod=1
+permod=1
+geomod=0
+rdsmod=0
+tempmod=0
+lintnoi=0
+vfbsdoff=0
+lambda=0
+vtl=0
+lc=5e-09
+xn=3
+rnoia=0.69
+rnoib=0.34
+tnoia=2.5e+07
+tnoib=0
+epsrox=3.9
+toxe={4.23e-09+MC_MM_SWITCH*my_gauss*(4.23e-09*(0.02389/sqrt(l*w*m)))}
+dtox=0
+ndep=1.7e+17
+nsd=1e+20
+rshg=0.1
+rsh=1
+vth0={(-1.782289999e-01+MC_MM_SWITCH*my_gauss*(0.009789/sqrt(l*w*m)))*4.84695}
+lvth0=-7.2226e-08
+wvth0=-1.34899e-07
+pvth0=4.95464e-14
+k1=0.64774
+k2=-0.0469552
+lk2=4.07195e-09
+wk2=-1.04826e-08
+pk2=6.07382e-15
+k3=3.39
+dvt0={2.4422*1}
+dvt1={0.16136*1}
+dvt2=0.026237
+dvt0w=0.5
+dvt1w=1.9281e+06
+dvt2w=-0.032
+w0=1e-08
+k3b=1
+phin=0
+lpe0=0
+lpeb=0
+vbm=-3
+dvtp0=0
+dvtp1=0
+vsat={1.729186447e+05*4114.3}
+lvsat=-0.0197666
+wvsat=-0.063004
+pvsat=1.73353e-08
+ua={-3.076683126e-09*1}
+lua=6.22987e-17
+wua=2.38601e-16
+pua=-1.06094e-22
+ub={2.612994519e-18*1}
+lub=1.90597e-25
+wub=-8.03643e-26
+pub=6.11569e-32
+uc={1.607392219e-11*1}
+luc=1.38059e-17
+wuc=4.01526e-17
+puc=-1.35994e-23
+rdsw={484.7*4.40825}
+prwb=0.1
+prwg={0.052*1}
+wr=1
+u0={9.335311068e-04*9.99882}
+lu0=6.55387e-10
+wu0=1.17079e-09
+pu0=-4.00582e-16
+a0=1.1627
+keta=-0.0172723
+lketa=1.87604e-09
+wketa=2.91455e-09
+pketa=-1.00377e-15
+a1=0
+a2=0.467037
+ags=-0.744608
+lags=3.52307e-07
+wags=9.86593e-07
+pags=-3.47039e-13
+b0=7.89468e-07
+lb0=-4.0417e-13
+wb0=-7.3862e-13
+pb0=3.25156e-19
+b1=-1.8417e-06
+lb1=7.89471e-13
+wb1=1.71162e-12
+pb1=-6.72514e-19
+eu=1.67
+rdswmin=0
+rdw={1e-12*1}
+rdwmin=0
+rsw={1e-12*1}
+rswmin=0
+voff={-0.1819+MC_MM_SWITCH*my_gauss*(0/sqrt(l*w*m))}
+nfactor={(2.5373+MC_MM_SWITCH*my_gauss*(0/sqrt(l*w*m)))*16.6503}
+up=0
+ud=0
+lp=1
+tvfbsdoff=0
+tvoff=0
+cit=-6.39311e-11
+cdsc=2.8125e-07
+cdscb=0.0001
+cdscd=1e-10
+eta0={0.2*1}
+etab=-0.00025
+dsub={1.0*1}
+voffl=0
+minv=0
+pclm={0.030097*1}
+pdiblc1=0
+pdiblc2=-0.00270378
+lpdiblc2=9.64094e-09
+wpdiblc2=-4.49e-08
+ppdiblc2=3.81473e-14
+pdiblcb=-0.025
+drout=0.43496
+pscbe1=8e+08
+pscbe2=8.6797e-09
+pvag={1e-12*1}
+delta={1.509909476e-01*1}
+ldelta=-2.80051e-08
+wdelta=-6.54511e-08
+pdelta=1.65243e-14
+alpha0=5.04495e-13
+alpha1=-4.05837e-18
+beta0=6.20165
+fprout=0
+pdits=0
+pditsl=0
+pditsd=0
+agidl=0
+bgidl=2.3e+09
+cgidl=0.5
+egidl=0.8
+aigbacc=0.43
+bigbacc=0.054
+cigbacc=0.075
+nigbacc=1
+aigbinv=0.35
+bigbinv=0.03
+cigbinv=0.006
+eigbinv=1.1
+nigbinv=3
+aigc=0.43
+bigc=0.054
+cigc=0.075
+nigc=1
+aigsd=0.43
+bigsd=0.054
+cigsd=0.075
+dlcig=0
+poxedge=1
+pigcd=1
+ntox=1
+toxref=4.23e-09
+kt1=0
+lkt1=0
+wkt1=0
+pkt1=0
+kt2=0
+lkt2=0
+wkt2=0
+pkt2=0
+at=0
+lat=0
+wat=0
+pat=0
+ute=0
+lute=0
+wute=0
+pute=0
+ua1=0
+lua1=0
+wua1=0
+pua1=0
+ub1=0
+lub1=0
+wub1=0
+pub1=0
+uc1=0
+luc1=0
+wuc1=0
+puc1=0
+kt1l=0
+prt=0
+xrcrg1=12
+xrcrg2=1
+rbpb=50
+rbpd=50
+rbps=50
+rbdb=50
+rbsb=50
+gbmin=1e-12
+noia=3e+41
+noib=0
+noic=0
+em=4.1e+07
+af=1
+ef=0.88
+kf=0
+ntnoi=1
+dmcg=0
+dmcgt=0
+dmdg=0
+xgw=0
+xgl=0
+ngcon=1
+diomod=1
+njs=1.3632
+jss=2.1483e-05
+jsws=1.4472e-10
+xtis=0
+bvs=12.69
+xjbvs=1
+ijthsrev=0.1
+ijthsfwd=0.1
+tpb=0.001671
+tpbsw=0.001246
+tpbswg=0
+tcj=0.0012407
+tcjsw=0.00037357
+tcjswg=2e-12
+cgdo=2e-11
+cgso=2e-11
+cgbo=1e-13
+capmod=2
+xpart=0
+cgsl=0
+cgdl=0
+cf=0
+clc=7e-08
+cle=0.492
+dlc=-1.2e-08
+dwc=0
+vfbcv=-1
+acde=0.44
+moin=8.7
+noff=2.6123
+voffcv=0.112
+ngate=1e+23
+lwc=0
+llc=0
+lwlc=0
+wlc=0
+wwc=0
+wwlc=0
+ckappas=0.6
+cjs=0.000765357
+mjs=0.3362
+pbs=0.6587
+cjsws=9.16024e-11
+mjsws=0.2659
+pbsws=0.7418
+cjswgs=2.39155e-10
+mjswgs=0.9274
+pbswgs=1.4338
+saref=1.44e-06
+sbref=1.44e-06
+wlod={0+sky130_fd_pr__pfet_01v8_lvt__wlod_diff}
+kvth0={0+sky130_fd_pr__pfet_01v8_lvt__kvth0_diff}
+lkvth0={0+sky130_fd_pr__pfet_01v8_lvt__lkvth0_diff}
+wkvth0={0+sky130_fd_pr__pfet_01v8_lvt__wkvth0_diff}
+pkvth0=0
+llodvth=0
+wlodvth=1
+stk2=0
+lodk2=1
+lodeta0=1
+ku0={0+sky130_fd_pr__pfet_01v8_lvt__ku0_diff}
+lku0={0+sky130_fd_pr__pfet_01v8_lvt__lku0_diff}
+wku0={0+sky130_fd_pr__pfet_01v8_lvt__wku0_diff}
+pku0=0
+llodku0=0
+wlodku0=1
+kvsat={0+sky130_fd_pr__pfet_01v8_lvt__kvsat_diff}
+steta0=0
+tku0=0
+ucste=0
+lucste=0
+wucste=0
+pucste=0
* DC IV MOS Parameters
* BSIM4 - Model Selectors
* BSIM4 - Process Parameters
*(mismatch parameter 0)
* Threshold Voltage Parameters
*(mismatch parameter 0)
* NEW BSIM4 Parameters for Level 54
* Mobility Parameters
* BSIM4 - Mobility Parameters
* Subthreshold Current Parameters
*(mismatch parameter 0)
*(mismatch parameter 0)
* BSIM4 - Sub-threshold parameters
* Rout Parameters
* BSIM4 - Rout Parameters
* BSIM4 - Gate Induced Drain Leakage Model Parameters
* BSIM4 - Gate Leakage Current Parameters
* Temperature Effects Parameters
* BSIM4 - High Speed RF Model Parameters
* BSIM4 - Flicker and Thermal Noise Parameters
* BSIM4 - Layout Dependent Parasitic Model Parameters
* Diode DC IV Parameters
* BSIM4 - Diode DC IV parameters
* Diode and FET Capacitance Parameters
* BSIM4 - FET and Diode capacitance parameters
* Stress Parameters

.model sky130_fd_pr__pfet_01v8_lvt__model.6 pmos
+lmin=4e-06
+lmax=8e-06
+wmin=1e-06
+wmax=3e-06
+level=54
+tnom=-196.15
+version=4.82
+toxm=4.23e-09
+xj=1.5e-07
+lln=1
+lwn=1
+wln=1
+wwn=1
+lint=2.8e-09
+ll=0
+lw=0
+lwl=0
+wint=7.476e-09
+wl=0
+ww=0
+wwl=0
+xl=0
+xw=0
+mobmod=0
+binunit=2
+dwg=-7.916e-09
+dwb=0
+igcmod=0
+igbmod=0
+rgatemod=0
+rbodymod=1
+trnqsmod=0
+acnqsmod=0
+fnoimod=1
+tnoimod=1
+permod=1
+geomod=0
+rdsmod=0
+tempmod=0
+lintnoi=0
+vfbsdoff=0
+lambda=0
+vtl=0
+lc=5e-09
+xn=3
+rnoia=0.69
+rnoib=0.34
+tnoia=2.5e+07
+tnoib=0
+epsrox=3.9
+toxe={4.23e-09+MC_MM_SWITCH*my_gauss*(4.23e-09*(0.003689/sqrt(l*w*m)))}
+dtox=0
+ndep=1.7e+17
+nsd=1e+20
+rshg=0.1
+rsh=1
+vth0={(-4.703840235e-01+MC_MM_SWITCH*my_gauss*(0.01389/sqrt(l*w*m)))*2.54819}
+lvth0=1.63504e-07
+wvth0=5.12607e-08
+pvth0=-4.79901e-14
+k1=0.64774
+k2=-0.056175
+lk2=4.18131e-08
+wk2=1.56914e-08
+pk2=-2.86734e-14
+k3=3.39
+dvt0={2.4422*1}
+dvt1={0.16136*1}
+dvt2=0.026237
+dvt0w=0.5
+dvt1w=1.9281e+06
+dvt2w=-0.032
+w0=1e-08
+k3b=1
+phin=0
+lpe0=0
+lpeb=0
+vbm=-3
+dvtp0=0
+dvtp1=0
+vsat={123760.0*4404.24}
+ua={-2.824985027e-09*1}
+lua=-1.60858e-16
+wua=-1.12147e-17
+pua=-2.34739e-22
+ub={2.914554195e-18*1}
+lub=-3.26349e-25
+wub=-5.65792e-26
+pub=9.74169e-31
+uc={5.912933226e-11*1}
+wuc=5.37508e-18
+rdsw={484.7*24.9335}
+prwb=0.1
+prwg={0.052*1}
+wr=1
+u0={3.037702044e-03*8.34883}
+lu0=-1.63685e-09
+wu0=-4.80417e-10
+pu0=1.66899e-15
+a0=1.85836
+la0=1.6832e-07
+wa0=-4.70237e-07
+pa0=5.70206e-13
+keta=-0.01258
+a1=0
+a2=0.467037
+ags=0.365867
+lags=2.61339e-07
+wags=-1.37711e-07
+pags=1.29729e-13
+b0=0
+b1=2.1073e-24
+eu=1.67
+rdswmin=0
+rdw={1e-12*1}
+rdwmin=0
+rsw={1e-12*1}
+rswmin=0
+voff={-0.1819+MC_MM_SWITCH*my_gauss*(0/sqrt(l*w*m))}
+nfactor={(2.5373+MC_MM_SWITCH*my_gauss*(0/sqrt(l*w*m)))*11.0919}
+up=0
+ud=0
+lp=1
+tvfbsdoff=0
+tvoff=0
+cit=-6.39311e-11
+cdsc=2.8125e-07
+cdscb=0.0001
+cdscd=1e-10
+eta0={0.2*1}
+etab=-0.00025
+dsub={1.0*1}
+voffl=0
+minv=0
+pclm={0.030097*1}
+pdiblc1=0
+pdiblc2=0.00276795
+lpdiblc2=-7.91843e-10
+wpdiblc2=-4.49033e-09
+ppdiblc2=2.58436e-14
+pdiblcb=-0.025
+drout=0.43496
+pscbe1=8e+08
+pscbe2=8.6797e-09
+pvag={1e-12*1}
+delta={1.901431008e-02*1}
+ldelta=4.37668e-08
+wdelta=-1.56018e-08
+pdelta=3.35208e-14
+alpha0=5.04495e-13
+alpha1=-4.05837e-18
+beta0=6.20165
+fprout=0
+pdits=0
+pditsl=0
+pditsd=0
+agidl=0
+bgidl=2.3e+09
+cgidl=0.5
+egidl=0.8
+aigbacc=0.43
+bigbacc=0.054
+cigbacc=0.075
+nigbacc=1
+aigbinv=0.35
+bigbinv=0.03
+cigbinv=0.006
+eigbinv=1.1
+nigbinv=3
+aigc=0.43
+bigc=0.054
+cigc=0.075
+nigc=1
+aigsd=0.43
+bigsd=0.054
+cigsd=0.075
+dlcig=0
+poxedge=1
+pigcd=1
+ntox=1
+toxref=4.23e-09
+kt1=0
+lkt1=0
+wkt1=0
+pkt1=0
+kt2=0
+at=0
+lat=0
+wat=0
+pat=0
+ute=0
+lute=0
+ua1=0
+lua1=0
+ub1=0
+lub1=0
+wub1=0
+pub1=0
+uc1=0
+kt1l=0
+prt=0
+xrcrg1=12
+xrcrg2=1
+rbpb=50
+rbpd=50
+rbps=50
+rbdb=50
+rbsb=50
+gbmin=1e-12
+noia=3e+41
+noib=0
+noic=0
+em=4.1e+07
+af=1
+ef=0.88
+kf=0
+ntnoi=1
+dmcg=0
+dmcgt=0
+dmdg=0
+xgw=0
+xgl=0
+ngcon=1
+diomod=1
+njs=1.3632
+jss=2.1483e-05
+jsws=1.4472e-10
+xtis=0
+bvs=12.69
+xjbvs=1
+ijthsrev=0.1
+ijthsfwd=0.1
+tpb=0.001671
+tpbsw=0.001246
+tpbswg=0
+tcj=0.0012407
+tcjsw=0.00037357
+tcjswg=2e-12
+cgdo=2e-11
+cgso=2e-11
+cgbo=1e-13
+capmod=2
+xpart=0
+cgsl=0
+cgdl=0
+cf=0
+clc=7e-08
+cle=0.492
+dlc=-1.2e-08
+dwc=0
+vfbcv=-1
+acde=0.44
+moin=8.7
+noff=2.6123
+voffcv=0.112
+ngate=1e+23
+lwc=0
+llc=0
+lwlc=0
+wlc=0
+wwc=0
+wwlc=0
+ckappas=0.6
+cjs=0.000765357
+mjs=0.3362
+pbs=0.6587
+cjsws=9.16024e-11
+mjsws=0.2659
+pbsws=0.7418
+cjswgs=2.39155e-10
+mjswgs=0.9274
+pbswgs=1.4338
+saref=3e-06
+sbref=3e-06
+wlod={0+sky130_fd_pr__pfet_01v8_lvt__wlod_diff}
+kvth0={0+sky130_fd_pr__pfet_01v8_lvt__kvth0_diff}
+lkvth0={0+sky130_fd_pr__pfet_01v8_lvt__lkvth0_diff}
+wkvth0={0+sky130_fd_pr__pfet_01v8_lvt__wkvth0_diff}
+pkvth0=0
+llodvth=0
+wlodvth=1
+stk2=0
+lodk2=1
+lodeta0=1
+ku0={0+sky130_fd_pr__pfet_01v8_lvt__ku0_diff}
+lku0={0+sky130_fd_pr__pfet_01v8_lvt__lku0_diff}
+wku0={0+sky130_fd_pr__pfet_01v8_lvt__wku0_diff}
+pku0=0
+llodku0=0
+wlodku0=1
+kvsat={0+sky130_fd_pr__pfet_01v8_lvt__kvsat_diff}
+steta0=0
+tku0=0
+lkt2=0
+wkt2=0
+pkt2=0
+wute=0
+pute=0
+wua1=0
+pua1=0
+luc1=0
+wuc1=0
+puc1=0
+ucste=0
+lucste=0
+wucste=0
+pucste=0
* DC IV MOS Parameters
* BSIM4 - Model Selectors
* BSIM4 - Process Parameters
*(mismatch parameter 0)
* Threshold Voltage Parameters
*(mismatch parameter 0)
* NEW BSIM4 Parameters for Level 54
* Mobility Parameters
* BSIM4 - Mobility Parameters
* Subthreshold Current Parameters
*(mismatch parameter 0)
*(mismatch parameter 0)
* BSIM4 - Sub-threshold parameters
* Rout Parameters
* BSIM4 - Rout Parameters
* BSIM4 - Gate Induced Drain Leakage Model Parameters
* BSIM4 - Gate Leakage Current Parameters
* Temperature Effects Parameters
* BSIM4 - High Speed RF Model Parameters
* BSIM4 - Flicker and Thermal Noise Parameters
* BSIM4 - Layout Dependent Parasitic Model Parameters
* Diode DC IV Parameters
* BSIM4 - Diode DC IV parameters
* Diode and FET Capacitance Parameters
* BSIM4 - FET and Diode capacitance parameters
* Stress Parameters

.model sky130_fd_pr__pfet_01v8_lvt__model.7 pmos
+lmin=3.5e-07
+lmax=5e-07
+wmin=4.2e-07
+wmax=5.5e-07
+level=54
+tnom=-196.15
+version=4.82
+toxm=4.23e-09
+xj=1.5e-07
+lln=1
+lwn=1
+wln=1
+wwn=1
+lint=2.8e-09
+ll=0
+lw=0
+lwl=0
+wint=7.476e-09
+wl=0
+ww=0
+wwl=0
+xl=0
+xw=0
+mobmod=0
+binunit=2
+dwg=-7.916e-09
+dwb=0
+igcmod=0
+igbmod=0
+rgatemod=0
+rbodymod=1
+trnqsmod=0
+acnqsmod=0
+fnoimod=1
+tnoimod=1
+permod=1
+geomod=0
+rdsmod=0
+tempmod=0
+lintnoi=0
+vfbsdoff=0
+lambda=0
+vtl=0
+lc=5e-09
+xn=3
+rnoia=0.69
+rnoib=0.34
+tnoia=2.5e+07
+tnoib=0
+epsrox=3.9
+toxe={4.23e-09+MC_MM_SWITCH*my_gauss*(4.23e-09*(0.02389/sqrt(l*w*m)))}
+dtox=0
+ndep=1.7e+17
+nsd=1e+20
+rshg=0.1
+rsh=1
+vth0={(-3.120368596e-01+MC_MM_SWITCH*my_gauss*(0.009789/sqrt(l*w*m)))*3.48149}
+lvth0=-7.47789e-08
+wvth0=-6.33049e-08
+pvth0=5.09123e-14
+k1=0.64774
+k2=-0.0358492
+lk2=-1.01835e-08
+wk2=-1.64249e-08
+pk2=1.37011e-14
+k3=3.39
+dvt0={2.4422*1}
+dvt1={0.16136*1}
+dvt2=0.026237
+dvt0w=0.5
+dvt1w=1.9281e+06
+dvt2w=-0.032
+w0=1e-08
+k3b=1
+phin=0
+lpe0=0
+lpeb=0
+vbm=-3
+dvtp0=0
+dvtp1=0
+vsat={-4.914187452e+05*0.01}
+lvsat=0.174368
+wvsat=0.292448
+pvsat=-8.65362e-08
+ua={-2.073443004e-09*1}
+lua=-3.44663e-16
+wua=-2.9818e-16
+pua=1.1165e-22
+ub={1.320790852e-18*1}
+lub=7.95103e-25
+wub=6.11027e-25
+pub=-2.62283e-31
+uc={7.979688230e-11*1}
+luc=-1.62623e-17
+wuc=6.05776e-18
+puc=2.48847e-24
+rdsw={484.7*7.37549}
+prwb=0.1
+prwg={0.052*1}
+wr=1
+u0={2.842284075e-03*16.941}
+lu0=1.42327e-11
+wu0=1.49511e-10
+pu0=-5.75337e-17
+a0=-0.478368
+wa0=8.7805e-07
+keta=-0.00947261
+wketa=-1.25864e-09
+a1=0
+a2=0.467037
+ags=4.04965
+lags=-1.21952e-06
+wags=-1.57856e-06
+pags=4.93966e-13
+b0=-4.8523e-07
+lb0=1.67113e-13
+wb0=-5.65953e-14
+pb0=1.94914e-20
+b1=3.41243e-06
+lb1=-1.17524e-12
+wb1=-1.0996e-12
+pb1=3.78701e-19
+eu=1.67
+rdswmin=0
+rdw={1e-12*1}
+rdwmin=0
+rsw={1e-12*1}
+rswmin=0
+voff={-0.1819+MC_MM_SWITCH*my_gauss*(0/sqrt(l*w*m))}
+nfactor={(2.5373+MC_MM_SWITCH*my_gauss*(0/sqrt(l*w*m)))*1}
+up=0
+ud=0
+lp=1
+tvfbsdoff=0
+tvoff=0
+cit=-6.39311e-11
+cdsc=2.8125e-07
+cdscb=0.0001
+cdscd=1e-10
+eta0={0.2*1}
+etab=-0.00025
+dsub={1.0*1}
+voffl=0
+minv=0
+pclm={-7.207791588e-02*1}
+wpclm=5.46685e-08
+pdiblc1=0
+pdiblc2=-0.0756607
+lpdiblc2=1.31005e-07
+wpdiblc2=-5.86449e-09
+ppdiblc2=-2.67884e-14
+pdiblcb=-0.025
+drout=0.462067
+wdrout=-1.45036e-08
+pscbe1=8e+08
+pscbe2=8.6797e-09
+pvag={1e-12*1}
+delta={1.275507657e-01*1}
+ldelta=-7.7248e-08
+wdelta=-5.29095e-08
+pdelta=4.28717e-14
+alpha0=5.04495e-13
+alpha1=-4.05837e-18
+beta0=6.20165
+fprout=0
+pdits=0
+pditsl=0
+pditsd=0
+agidl=0
+bgidl=2.3e+09
+cgidl=0.5
+egidl=0.8
+aigbacc=0.43
+bigbacc=0.054
+cigbacc=0.075
+nigbacc=1
+aigbinv=0.35
+bigbinv=0.03
+cigbinv=0.006
+eigbinv=1.1
+nigbinv=3
+aigc=0.43
+bigc=0.054
+cigc=0.075
+nigc=1
+aigsd=0.43
+bigsd=0.054
+cigsd=0.075
+dlcig=0
+poxedge=1
+pigcd=1
+ntox=1
+toxref=4.23e-09
+kt1=0
+lkt1=0
+wkt1=0
+pkt1=0
+kt2=0
+at=0
+lat=0
+wat=0
+pat=0
+ute=0
+lute=0
+ua1=0
+lua1=0
+wua1=0
+pua1=0
+ub1=0
+lub1=0
+wub1=0
+pub1=0
+uc1=0
+kt1l=0
+prt=0
+xrcrg1=12
+xrcrg2=1
+rbpb=50
+rbpd=50
+rbps=50
+rbdb=50
+rbsb=50
+gbmin=1e-12
+noia=3e+41
+noib=0
+noic=0
+em=4.1e+07
+af=1
+ef=0.88
+kf=0
+ntnoi=1
+dmcg=0
+dmcgt=0
+dmdg=0
+xgw=0
+xgl=0
+ngcon=1
+diomod=1
+njs=1.3632
+jss=2.1483e-05
+jsws=1.4472e-10
+xtis=0
+bvs=12.69
+xjbvs=1
+ijthsrev=0.1
+ijthsfwd=0.1
+tpb=0.001671
+tpbsw=0.001246
+tpbswg=0
+tcj=0.0012407
+tcjsw=0.00037357
+tcjswg=2e-12
+cgdo=2e-11
+cgso=2e-11
+cgbo=1e-13
+capmod=2
+xpart=0
+cgsl=0
+cgdl=0
+cf=0
+clc=7e-08
+cle=0.492
+dlc=-1.2e-08
+dwc=0
+vfbcv=-1
+acde=0.44
+moin=8.7
+noff=2.6123
+voffcv=0.112
+ngate=1e+23
+lwc=0
+llc=0
+lwlc=0
+wlc=0
+wwc=0
+wwlc=0
+ckappas=0.6
+cjs=0.000765357
+mjs=0.3362
+pbs=0.6587
+cjsws=9.16024e-11
+mjsws=0.2659
+pbsws=0.7418
+cjswgs=2.39155e-10
+mjswgs=0.9274
+pbswgs=1.4338
+saref=1.44e-06
+sbref=1.44e-06
+wlod={0+sky130_fd_pr__pfet_01v8_lvt__wlod_diff}
+kvth0={0+sky130_fd_pr__pfet_01v8_lvt__kvth0_diff}
+lkvth0={0+sky130_fd_pr__pfet_01v8_lvt__lkvth0_diff}
+wkvth0={0+sky130_fd_pr__pfet_01v8_lvt__wkvth0_diff}
+pkvth0=0
+llodvth=0
+wlodvth=1
+stk2=0
+lodk2=1
+lodeta0=1
+ku0={0+sky130_fd_pr__pfet_01v8_lvt__ku0_diff}
+lku0={0+sky130_fd_pr__pfet_01v8_lvt__lku0_diff}
+wku0={0+sky130_fd_pr__pfet_01v8_lvt__wku0_diff}
+pku0=0
+llodku0=0
+wlodku0=1
+kvsat={0+sky130_fd_pr__pfet_01v8_lvt__kvsat_diff}
+steta0=0
+tku0=0
+lkt2=0
+wkt2=0
+pkt2=0
+wute=0
+pute=0
+luc1=0
+wuc1=0
+puc1=0
+ucste=0
+lucste=0
+wucste=0
+pucste=0
* DC IV MOS Parameters
* BSIM4 - Model Selectors
* BSIM4 - Process Parameters
*(mismatch parameter 0)
* Threshold Voltage Parameters
*(mismatch parameter 0)
* NEW BSIM4 Parameters for Level 54
* Mobility Parameters
* BSIM4 - Mobility Parameters
* Subthreshold Current Parameters
*(mismatch parameter 0)
*(mismatch parameter 0)
* BSIM4 - Sub-threshold parameters
* Rout Parameters
* BSIM4 - Rout Parameters
* BSIM4 - Gate Induced Drain Leakage Model Parameters
* BSIM4 - Gate Leakage Current Parameters
* Temperature Effects Parameters
* BSIM4 - High Speed RF Model Parameters
* BSIM4 - Flicker and Thermal Noise Parameters
* BSIM4 - Layout Dependent Parasitic Model Parameters
* Diode DC IV Parameters
* BSIM4 - Diode DC IV parameters
* Diode and FET Capacitance Parameters
* BSIM4 - FET and Diode capacitance parameters
* Stress Parameters

.model sky130_fd_pr__pfet_01v8_lvt__model.8 pmos
+lmin=4e-06
+lmax=8e-06
+wmin=5.5e-07
+wmax=1e-06
+level=54
+tnom=-196.15
+version=4.82
+toxm=4.23e-09
+xj=1.5e-07
+lln=1
+lwn=1
+wln=1
+wwn=1
+lint=2.8e-09
+ll=0
+lw=0
+lwl=0
+wint=7.476e-09
+wl=0
+ww=0
+wwl=0
+xl=0
+xw=0
+mobmod=0
+binunit=2
+dwg=-7.916e-09
+dwb=0
+igcmod=0
+igbmod=0
+rgatemod=0
+rbodymod=1
+trnqsmod=0
+acnqsmod=0
+fnoimod=1
+tnoimod=1
+permod=1
+geomod=0
+rdsmod=0
+tempmod=0
+lintnoi=0
+vfbsdoff=0
+lambda=0
+vtl=0
+lc=5e-09
+xn=3
+rnoia=0.69
+rnoib=0.34
+tnoia=2.5e+07
+tnoib=0
+epsrox=3.9
+toxe={4.23e-09+MC_MM_SWITCH*my_gauss*(4.23e-09*(0.003689/sqrt(l*w*m)))}
+dtox=0
+ndep=1.7e+17
+nsd=1e+20
+rshg=0.1
+rsh=1
+vth0={(-4.523512713e-01+MC_MM_SWITCH*my_gauss*(0.009789/sqrt(l*w*m)))*2.63399}
+lvth0=1.40465e-07
+wvth0=3.34975e-08
+pvth0=-2.52957e-14
+k1=0.64774
+k2=-0.0510582
+lk2=1.20207e-09
+wk2=1.0651e-08
+pk2=1.13304e-14
+k3=3.39
+dvt0={2.4422*1}
+dvt1={0.16136*1}
+dvt2=0.026237
+dvt0w=0.5
+dvt1w=1.9281e+06
+dvt2w=-0.032
+w0=1e-08
+k3b=1
+phin=0
+lpe0=0
+lpeb=0
+vbm=-3
+dvtp0=0
+dvtp1=0
+vsat={123760.0*4933.4}
+ua={-2.653280831e-09*1}
+lua=-4.91233e-16
+wua=-1.80352e-16
+pua=9.06957e-23
+ub={2.632245133e-18*1}
+lub=1.15809e-24
+wub=2.21509e-25
+pub=-4.88074e-31
+uc={6.354273773e-11*1}
+luc=5.13137e-17
+wuc=1.02766e-18
+puc=-5.05465e-23
+rdsw={484.7*59.2967}
+prwb=0.1
+prwg={0.052*1}
+wr=1
+u0={2.753211559e-03*11.6046}
+lu0=1.13005e-09
+wu0=-2.0018e-10
+pu0=-1.05654e-15
+a0=0.932293
+la0=1.96305e-06
+wa0=4.41981e-07
+pa0=-1.19769e-12
+keta=-0.01258
+a1=0
+a2=0.467037
+ags=0.14882
+lags=1.11152e-06
+wags=7.60905e-08
+pags=-7.07735e-13
+b0=2.33781e-08
+lb0=6.10563e-13
+wb0=-2.30285e-14
+pb0=-6.01434e-19
+b1=-2.45025e-07
+lb1=1.80348e-14
+wb1=2.41361e-13
+pb1=-1.77651e-20
+eu=1.67
+rdswmin=0
+rdw={1e-12*1}
+rdwmin=0
+rsw={1e-12*1}
+rswmin=0
+voff={-0.1819+MC_MM_SWITCH*my_gauss*(0/sqrt(l*w*m))}
+nfactor={(2.5373+MC_MM_SWITCH*my_gauss*(0/sqrt(l*w*m)))*15.4893}
+up=0
+ud=0
+lp=1
+tvfbsdoff=0
+tvoff=0
+cit=-6.39311e-11
+cdsc=2.8125e-07
+cdscb=0.0001
+cdscd=1e-10
+eta0={0.2*1}
+etab=-0.00025
+dsub={1.0*1}
+voffl=0
+minv=0
+pclm={0.030097*1}
+pdiblc1=0
+pdiblc2=-0.0012947
+lpdiblc2=3.05984e-08
+wpdiblc2=-4.88421e-10
+ppdiblc2=-5.07728e-15
+pdiblcb=-0.025
+drout=0.43496
+pscbe1=8e+08
+pscbe2=8.6797e-09
+pvag={1e-12*1}
+delta={-3.869901880e-03*1}
+ldelta=1.27781e-07
+wdelta=6.9402e-09
+pdelta=-4.92375e-14
+alpha0=5.04495e-13
+alpha1=-4.05837e-18
+beta0=6.20165
+fprout=0
+pdits=0
+pditsl=0
+pditsd=0
+agidl=0
+bgidl=2.3e+09
+cgidl=0.5
+egidl=0.8
+aigbacc=0.43
+bigbacc=0.054
+cigbacc=0.075
+nigbacc=1
+aigbinv=0.35
+bigbinv=0.03
+cigbinv=0.006
+eigbinv=1.1
+nigbinv=3
+aigc=0.43
+bigc=0.054
+cigc=0.075
+nigc=1
+aigsd=0.43
+bigsd=0.054
+cigsd=0.075
+dlcig=0
+poxedge=1
+pigcd=1
+ntox=1
+toxref=4.23e-09
+kt1=0
+lkt1=0
+wkt1=0
+pkt1=0
+kt2=0
+at=0
+lat=0
+wat=0
+pat=0
+ute=0
+lute=0
+wute=0
+pute=0
+ua1=0
+lua1=0
+ub1=0
+lub1=0
+wub1=0
+pub1=0
+uc1=0
+kt1l=0
+prt=0
+xrcrg1=12
+xrcrg2=1
+rbpb=50
+rbpd=50
+rbps=50
+rbdb=50
+rbsb=50
+gbmin=1e-12
+noia=3e+41
+noib=0
+noic=0
+em=4.1e+07
+af=1
+ef=0.88
+kf=0
+ntnoi=1
+dmcg=0
+dmcgt=0
+dmdg=0
+xgw=0
+xgl=0
+ngcon=1
+diomod=1
+njs=1.3632
+jss=2.1483e-05
+jsws=1.4472e-10
+xtis=0
+bvs=12.69
+xjbvs=1
+ijthsrev=0.1
+ijthsfwd=0.1
+tpb=0.001671
+tpbsw=0.001246
+tpbswg=0
+tcj=0.0012407
+tcjsw=0.00037357
+tcjswg=2e-12
+cgdo=2e-11
+cgso=2e-11
+cgbo=1e-13
+capmod=2
+xpart=0
+cgsl=0
+cgdl=0
+cf=0
+clc=7e-08
+cle=0.492
+dlc=-1.2e-08
+dwc=0
+vfbcv=-1
+acde=0.44
+moin=8.7
+noff=2.6123
+voffcv=0.112
+ngate=1e+23
+lwc=0
+llc=0
+lwlc=0
+wlc=0
+wwc=0
+wwlc=0
+ckappas=0.6
+cjs=0.000765357
+mjs=0.3362
+pbs=0.6587
+cjsws=9.16024e-11
+mjsws=0.2659
+pbsws=0.7418
+cjswgs=2.39155e-10
+mjswgs=0.9274
+pbswgs=1.4338
+saref=3e-06
+sbref=3e-06
+wlod={0+sky130_fd_pr__pfet_01v8_lvt__wlod_diff}
+kvth0={0+sky130_fd_pr__pfet_01v8_lvt__kvth0_diff}
+lkvth0={0+sky130_fd_pr__pfet_01v8_lvt__lkvth0_diff}
+wkvth0={0+sky130_fd_pr__pfet_01v8_lvt__wkvth0_diff}
+pkvth0=0
+llodvth=0
+wlodvth=1
+stk2=0
+lodk2=1
+lodeta0=1
+ku0={0+sky130_fd_pr__pfet_01v8_lvt__ku0_diff}
+lku0={0+sky130_fd_pr__pfet_01v8_lvt__lku0_diff}
+wku0={0+sky130_fd_pr__pfet_01v8_lvt__wku0_diff}
+pku0=0
+llodku0=0
+wlodku0=1
+kvsat={0+sky130_fd_pr__pfet_01v8_lvt__kvsat_diff}
+steta0=0
+tku0=0
+lkt2=0
+wkt2=0
+pkt2=0
+wua1=0
+pua1=0
+luc1=0
+wuc1=0
+puc1=0
+ucste=0
+lucste=0
+wucste=0
+pucste=0
* DC IV MOS Parameters
* BSIM4 - Model Selectors
* BSIM4 - Process Parameters
*(mismatch parameter 0)
* Threshold Voltage Parameters
*(mismatch parameter 0)
* NEW BSIM4 Parameters for Level 54
* Mobility Parameters
* BSIM4 - Mobility Parameters
* Subthreshold Current Parameters
*(mismatch parameter 0)
*(mismatch parameter 0)
* BSIM4 - Sub-threshold parameters
* Rout Parameters
* BSIM4 - Rout Parameters
* BSIM4 - Gate Induced Drain Leakage Model Parameters
* BSIM4 - Gate Leakage Current Parameters
* Temperature Effects Parameters
* BSIM4 - High Speed RF Model Parameters
* BSIM4 - Flicker and Thermal Noise Parameters
* BSIM4 - Layout Dependent Parasitic Model Parameters
* Diode DC IV Parameters
* BSIM4 - Diode DC IV parameters
* Diode and FET Capacitance Parameters
* BSIM4 - FET and Diode capacitance parameters
* Stress Parameters

.model sky130_fd_pr__pfet_01v8_lvt__model.9 pmos
+lmin=3.5e-07
+lmax=5e-07
+wmin=3e-06
+wmax=5e-06
+level=54
+tnom=-196.15
+version=4.82
+toxm=4.23e-09
+xj=1.5e-07
+lln=1
+lwn=1
+wln=1
+wwn=1
+lint=2.8e-09
+ll=0
+lw=0
+lwl=0
+wint=7.476e-09
+wl=0
+ww=0
+wwl=0
+xl=0
+xw=0
+mobmod=0
+binunit=2
+dwg=-7.916e-09
+dwb=0
+igcmod=0
+igbmod=0
+rgatemod=0
+rbodymod=1
+trnqsmod=0
+acnqsmod=0
+fnoimod=1
+tnoimod=1
+permod=1
+geomod=0
+rdsmod=0
+tempmod=0
+lintnoi=0
+vfbsdoff=0
+lambda=0
+vtl=0
+lc=5e-09
+xn=3
+rnoia=0.69
+rnoib=0.34
+tnoia=2.5e+07
+tnoib=0
+epsrox=3.9
+toxe={4.23e-09+MC_MM_SWITCH*my_gauss*(4.23e-09*(0.02389/sqrt(l*w*m)))}
+dtox=0
+ndep=1.7e+17
+nsd=1e+20
+rshg=0.1
+rsh=1
+vth0={(-4.077983629e-01+MC_MM_SWITCH*my_gauss*(0.009789/sqrt(l*w*m)))*3.00971}
+lvth0=-3.44989e-08
+wvth0=-1.84832e-07
+pvth0=1.77134e-13
+k1=0.64774
+k2=-0.0500569
+lk2=-3.35495e-09
+wk2=-9.30753e-08
+pk2=5.78817e-14
+k3=3.39
+dvt0={2.4422*1}
+dvt1={0.16136*1}
+dvt2=0.026237
+dvt0w=0.5
+dvt1w=1.9281e+06
+dvt2w=-0.032
+w0=1e-08
+k3b=1
+phin=0
+lpe0=0
+lpeb=0
+vbm=-3
+dvtp0=0
+dvtp1=0
+vsat={6.576482278e+05*4700.55}
+lvsat=-0.199793
+wvsat=-1.65028
+pvsat=6.14974e-07
+ua={-2.883571214e-09*1}
+lua=3.48919e-17
+wua=1.17316e-15
+pua=-5.78538e-22
+ub={2.725739067e-18*1}
+lub=1.01827e-25
+wub=-1.60921e-24
+pub=7.95595e-31
+uc={-1.338483519e-11*1}
+luc=3.28425e-17
+wuc=3.30929e-16
+puc=-1.46315e-22
+rdsw={484.7*6.17252}
+prwb=0.1
+prwg={0.052*1}
+wr=1
+u0={2.516996829e-03*11.8673}
+lu0=4.82327e-10
+wu0=1.55268e-09
+pu0=-1.29403e-15
+a0=5.71268
+la0=-1.87698e-06
+wa0=-1.18321e-05
+pa0=5.34081e-12
+keta=-0.01258
+a1=0
+a2=0.467037
+ags=-0.114211
+lags=2.5071e-07
+wags=1.25405e-06
+pags=-7.48383e-13
+b0=-4.78888e-06
+lb0=1.64929e-12
+wb0=3.4872e-12
+pb0=-1.20099e-18
+b1=2.1073e-24
+eu=1.67
+rdswmin=0
+rdw={1e-12*1}
+rdwmin=0
+rsw={1e-12*1}
+rswmin=0
+voff={-0.1819+MC_MM_SWITCH*my_gauss*(0/sqrt(l*w*m))}
+nfactor={(4.071697472e-01+MC_MM_SWITCH*my_gauss*(0/sqrt(l*w*m)))*50}
+wnfactor=1.06188e-05
+up=0
+ud=0
+lp=1
+tvfbsdoff=0
+tvoff=0
+cit=-6.39311e-11
+cdsc=2.8125e-07
+cdscb=0.0001
+cdscd=1e-10
+eta0={0.2*1}
+etab=-0.00025
+dsub={1.0*1}
+voffl=0
+minv=0
+pclm={0.030097*1}
+pdiblc1=0
+pdiblc2=-0.0309777
+lpdiblc2=4.62187e-08
+wpdiblc2=-1.48424e-07
+ppdiblc2=4.54722e-14
+pdiblcb=-0.025
+drout=0.43496
+pscbe1=8e+08
+pscbe2=8.6797e-09
+pvag={1e-12*1}
+delta={5.923589745e-02*1}
+ldelta=-8.92923e-09
+wdelta=-1.24242e-07
+pdelta=9.86554e-14
+alpha0=5.04495e-13
+alpha1=-4.05837e-18
+beta0=6.20165
+fprout=0
+pdits=0
+pditsl=0
+pditsd=0
+agidl=0
+bgidl=2.3e+09
+cgidl=0.5
+egidl=0.8
+aigbacc=0.43
+bigbacc=0.054
+cigbacc=0.075
+nigbacc=1
+aigbinv=0.35
+bigbinv=0.03
+cigbinv=0.006
+eigbinv=1.1
+nigbinv=3
+aigc=0.43
+bigc=0.054
+cigc=0.075
+nigc=1
+aigsd=0.43
+bigsd=0.054
+cigsd=0.075
+dlcig=0
+poxedge=1
+pigcd=1
+ntox=1
+toxref=4.23e-09
+kt1=0
+lkt1=0
+wkt1=0
+pkt1=0
+kt2=0
+lkt2=0
+wkt2=0
+pkt2=0
+at=0
+lat=0
+wat=0
+pat=0
+ute=0
+lute=0
+wute=0
+pute=0
+ua1=0
+ub1=0
+lub1=0
+wub1=0
+pub1=0
+uc1=0
+kt1l=0
+prt=0
+xrcrg1=12
+xrcrg2=1
+rbpb=50
+rbpd=50
+rbps=50
+rbdb=50
+rbsb=50
+gbmin=1e-12
+noia=3e+41
+noib=0
+noic=0
+em=4.1e+07
+af=1
+ef=0.88
+kf=0
+ntnoi=1
+dmcg=0
+dmcgt=0
+dmdg=0
+xgw=0
+xgl=0
+ngcon=1
+diomod=1
+njs=1.3632
+jss=2.1483e-05
+jsws=1.4472e-10
+xtis=0
+bvs=12.69
+xjbvs=1
+ijthsrev=0.1
+ijthsfwd=0.1
+tpb=0.001671
+tpbsw=0.001246
+tpbswg=0
+tcj=0.0012407
+tcjsw=0.00037357
+tcjswg=2e-12
+cgdo=2e-11
+cgso=2e-11
+cgbo=1e-13
+capmod=2
+xpart=0
+cgsl=0
+cgdl=0
+cf=0
+clc=7e-08
+cle=0.492
+dlc=-1.2e-08
+dwc=0
+vfbcv=-1
+acde=0.44
+moin=8.7
+noff=2.6123
+voffcv=0.112
+ngate=1e+23
+lwc=0
+llc=0
+lwlc=0
+wlc=0
+wwc=0
+wwlc=0
+ckappas=0.6
+cjs=0.000765357
+mjs=0.3362
+pbs=0.6587
+cjsws=9.16024e-11
+mjsws=0.2659
+pbsws=0.7418
+cjswgs=2.39155e-10
+mjswgs=0.9274
+pbswgs=1.4338
+saref=1.44e-06
+sbref=1.44e-06
+wlod={0+sky130_fd_pr__pfet_01v8_lvt__wlod_diff}
+kvth0={0+sky130_fd_pr__pfet_01v8_lvt__kvth0_diff}
+lkvth0={0+sky130_fd_pr__pfet_01v8_lvt__lkvth0_diff}
+wkvth0={0+sky130_fd_pr__pfet_01v8_lvt__wkvth0_diff}
+pkvth0=0
+llodvth=0
+wlodvth=1
+stk2=0
+lodk2=1
+lodeta0=1
+ku0={0+sky130_fd_pr__pfet_01v8_lvt__ku0_diff}
+lku0={0+sky130_fd_pr__pfet_01v8_lvt__lku0_diff}
+wku0={0+sky130_fd_pr__pfet_01v8_lvt__wku0_diff}
+pku0=0
+llodku0=0
+wlodku0=1
+kvsat={0+sky130_fd_pr__pfet_01v8_lvt__kvsat_diff}
+steta0=0
+tku0=0
+lua1=0
+wua1=0
+pua1=0
+luc1=0
+wuc1=0
+puc1=0
+ucste=0
+lucste=0
+wucste=0
+pucste=0
* DC IV MOS Parameters
* BSIM4 - Model Selectors
* BSIM4 - Process Parameters
*(mismatch parameter 0)
* Threshold Voltage Parameters
*(mismatch parameter 0)
* NEW BSIM4 Parameters for Level 54
* Mobility Parameters
* BSIM4 - Mobility Parameters
* Subthreshold Current Parameters
*(mismatch parameter 0)
*(mismatch parameter 0)
* BSIM4 - Sub-threshold parameters
* Rout Parameters
* BSIM4 - Rout Parameters
* BSIM4 - Gate Induced Drain Leakage Model Parameters
* BSIM4 - Gate Leakage Current Parameters
* Temperature Effects Parameters
* BSIM4 - High Speed RF Model Parameters
* BSIM4 - Flicker and Thermal Noise Parameters
* BSIM4 - Layout Dependent Parasitic Model Parameters
* Diode DC IV Parameters
* BSIM4 - Diode DC IV parameters
* Diode and FET Capacitance Parameters
* BSIM4 - FET and Diode capacitance parameters
* Stress Parameters

.model sky130_fd_pr__pfet_01v8_lvt__model.10 pmos
+lmin=3.5e-07
+lmax=5e-07
+wmin=4.2e-07
+wmax=5.5e-07
+level=54
+tnom=-196.15
+version=4.82
+toxm=4.23e-09
+xj=1.5e-07
+lln=1
+lwn=1
+wln=1
+wwn=1
+lint=2.8e-09
+ll=0
+lw=0
+lwl=0
+wint=7.476e-09
+wl=0
+ww=0
+wwl=0
+xl=0
+xw=0
+mobmod=0
+binunit=2
+dwg=-7.916e-09
+dwb=0
+igcmod=0
+igbmod=0
+rgatemod=0
+rbodymod=1
+trnqsmod=0
+acnqsmod=0
+fnoimod=1
+tnoimod=1
+permod=1
+geomod=0
+rdsmod=0
+tempmod=0
+lintnoi=0
+vfbsdoff=0
+lambda=0
+vtl=0
+lc=5e-09
+xn=3
+rnoia=0.69
+rnoib=0.34
+tnoia=2.5e+07
+tnoib=0
+epsrox=3.9
+toxe={4.23e-09+MC_MM_SWITCH*my_gauss*(4.23e-09*(0.02389/sqrt(l*w*m)))}
+dtox=0
+ndep=1.7e+17
+nsd=1e+20
+rshg=0.1
+rsh=1
+vth0={(-3.120368596e-01+MC_MM_SWITCH*my_gauss*(0.009789/sqrt(l*w*m)))*2.83706}
+lvth0=-7.47789e-08
+wvth0=-6.33049e-08
+pvth0=5.09123e-14
+k1=0.64774
+k2=-0.0358492
+lk2=-1.01835e-08
+wk2=-1.64249e-08
+pk2=1.37011e-14
+k3=3.39
+dvt0={2.4422*1}
+dvt1={0.16136*1}
+dvt2=0.026237
+dvt0w=0.5
+dvt1w=1.9281e+06
+dvt2w=-0.032
+w0=1e-08
+k3b=1
+phin=0
+lpe0=0
+lpeb=0
+vbm=-3
+dvtp0=0
+dvtp1=0
+vsat={-4.914187452e+05*0.0526208}
+lvsat=0.174368
+wvsat=0.292448
+pvsat=-8.65362e-08
+ua={-2.073443004e-09*1}
+lua=-3.44663e-16
+wua=-2.9818e-16
+pua=1.1165e-22
+ub={1.320790852e-18*1}
+lub=7.95103e-25
+wub=6.11027e-25
+pub=-2.62283e-31
+uc={7.979688230e-11*1}
+luc=-1.62623e-17
+wuc=6.05776e-18
+puc=2.48847e-24
+rdsw={484.7*0.0132645}
+prwb=0.1
+prwg={0.052*1}
+wr=1
+u0={2.842284075e-03*1.09137}
+lu0=1.42327e-11
+wu0=1.49511e-10
+pu0=-5.75337e-17
+a0=-0.478368
+wa0=8.7805e-07
+keta=-0.00947261
+wketa=-1.25864e-09
+a1=0
+a2=0.467037
+ags=4.04965
+lags=-1.21952e-06
+wags=-1.57856e-06
+pags=4.93966e-13
+b0=-4.8523e-07
+lb0=1.67113e-13
+wb0=-5.65953e-14
+pb0=1.94914e-20
+b1=3.41243e-06
+lb1=-1.17524e-12
+wb1=-1.0996e-12
+pb1=3.78701e-19
+eu=1.67
+rdswmin=0
+rdw={1e-12*1}
+rdwmin=0
+rsw={1e-12*1}
+rswmin=0
+voff={-0.1819+MC_MM_SWITCH*my_gauss*(0/sqrt(l*w*m))}
+nfactor={(2.5373+MC_MM_SWITCH*my_gauss*(0/sqrt(l*w*m)))*28.8009}
+up=0
+ud=0
+lp=1
+tvfbsdoff=0
+tvoff=0
+cit=-6.39311e-11
+cdsc=2.8125e-07
+cdscb=0.0001
+cdscd=1e-10
+eta0={0.2*1}
+etab=-0.00025
+dsub={1.0*1}
+voffl=0
+minv=0
+pclm={-7.207791588e-02*1}
+wpclm=5.46685e-08
+pdiblc1=0
+pdiblc2=-0.0756607
+lpdiblc2=1.31005e-07
+wpdiblc2=-5.86449e-09
+ppdiblc2=-2.67884e-14
+pdiblcb=-0.025
+drout=0.462067
+wdrout=-1.45036e-08
+pscbe1=8e+08
+pscbe2=8.6797e-09
+pvag={1e-12*1}
+delta={1.275507657e-01*1}
+ldelta=-7.7248e-08
+wdelta=-5.29095e-08
+pdelta=4.28717e-14
+alpha0=5.04495e-13
+alpha1=-4.05837e-18
+beta0=6.20165
+fprout=0
+pdits=0
+pditsl=0
+pditsd=0
+agidl=0
+bgidl=2.3e+09
+cgidl=0.5
+egidl=0.8
+aigbacc=0.43
+bigbacc=0.054
+cigbacc=0.075
+nigbacc=1
+aigbinv=0.35
+bigbinv=0.03
+cigbinv=0.006
+eigbinv=1.1
+nigbinv=3
+aigc=0.43
+bigc=0.054
+cigc=0.075
+nigc=1
+aigsd=0.43
+bigsd=0.054
+cigsd=0.075
+dlcig=0
+poxedge=1
+pigcd=1
+ntox=1
+toxref=4.23e-09
+kt1=0
+lkt1=0
+wkt1=0
+pkt1=0
+kt2=0
+at=0
+lat=0
+wat=0
+pat=0
+ute=0
+lute=0
+ua1=0
+lua1=0
+wua1=0
+pua1=0
+ub1=0
+lub1=0
+wub1=0
+pub1=0
+uc1=0
+kt1l=0
+prt=0
+xrcrg1=12
+xrcrg2=1
+rbpb=50
+rbpd=50
+rbps=50
+rbdb=50
+rbsb=50
+gbmin=1e-12
+noia=3e+41
+noib=0
+noic=0
+em=4.1e+07
+af=1
+ef=0.88
+kf=0
+ntnoi=1
+dmcg=0
+dmcgt=0
+dmdg=0
+xgw=0
+xgl=0
+ngcon=1
+diomod=1
+njs=1.3632
+jss=2.1483e-05
+jsws=1.4472e-10
+xtis=0
+bvs=12.69
+xjbvs=1
+ijthsrev=0.1
+ijthsfwd=0.1
+tpb=0.001671
+tpbsw=0.001246
+tpbswg=0
+tcj=0.0012407
+tcjsw=0.00037357
+tcjswg=2e-12
+cgdo=2e-11
+cgso=2e-11
+cgbo=1e-13
+capmod=2
+xpart=0
+cgsl=0
+cgdl=0
+cf=0
+clc=7e-08
+cle=0.492
+dlc=-1.2e-08
+dwc=0
+vfbcv=-1
+acde=0.44
+moin=8.7
+noff=2.6123
+voffcv=0.112
+ngate=1e+23
+lwc=0
+llc=0
+lwlc=0
+wlc=0
+wwc=0
+wwlc=0
+ckappas=0.6
+cjs=0.000765357
+mjs=0.3362
+pbs=0.6587
+cjsws=9.16024e-11
+mjsws=0.2659
+pbsws=0.7418
+cjswgs=2.39155e-10
+mjswgs=0.9274
+pbswgs=1.4338
+saref=1.44e-06
+sbref=1.44e-06
+wlod={0+sky130_fd_pr__pfet_01v8_lvt__wlod_diff}
+kvth0={0+sky130_fd_pr__pfet_01v8_lvt__kvth0_diff}
+lkvth0={0+sky130_fd_pr__pfet_01v8_lvt__lkvth0_diff}
+wkvth0={0+sky130_fd_pr__pfet_01v8_lvt__wkvth0_diff}
+pkvth0=0
+llodvth=0
+wlodvth=1
+stk2=0
+lodk2=1
+lodeta0=1
+ku0={0+sky130_fd_pr__pfet_01v8_lvt__ku0_diff}
+lku0={0+sky130_fd_pr__pfet_01v8_lvt__lku0_diff}
+wku0={0+sky130_fd_pr__pfet_01v8_lvt__wku0_diff}
+pku0=0
+llodku0=0
+wlodku0=1
+kvsat={0+sky130_fd_pr__pfet_01v8_lvt__kvsat_diff}
+steta0=0
+tku0=0
+lkt2=0
+wkt2=0
+pkt2=0
+wute=0
+pute=0
+luc1=0
+wuc1=0
+puc1=0
+ucste=0
+lucste=0
+wucste=0
+pucste=0
* DC IV MOS Parameters
* BSIM4 - Model Selectors
* BSIM4 - Process Parameters
*(mismatch parameter 0)
* Threshold Voltage Parameters
*(mismatch parameter 0)
* NEW BSIM4 Parameters for Level 54
* Mobility Parameters
* BSIM4 - Mobility Parameters
* Subthreshold Current Parameters
*(mismatch parameter 0)
*(mismatch parameter 0)
* BSIM4 - Sub-threshold parameters
* Rout Parameters
* BSIM4 - Rout Parameters
* BSIM4 - Gate Induced Drain Leakage Model Parameters
* BSIM4 - Gate Leakage Current Parameters
* Temperature Effects Parameters
* BSIM4 - High Speed RF Model Parameters
* BSIM4 - Flicker and Thermal Noise Parameters
* BSIM4 - Layout Dependent Parasitic Model Parameters
* Diode DC IV Parameters
* BSIM4 - Diode DC IV parameters
* Diode and FET Capacitance Parameters
* BSIM4 - FET and Diode capacitance parameters
* Stress Parameters

.model sky130_fd_pr__pfet_01v8_lvt__model.11 pmos
+lmin=2e-06
+lmax=4e-06
+wmin=3e-06
+wmax=5e-06
+level=54
+tnom=-196.15
+version=4.82
+toxm=4.23e-09
+xj=1.5e-07
+lln=1
+lwn=1
+wln=1
+wwn=1
+lint=2.8e-09
+ll=0
+lw=0
+lwl=0
+wint=7.476e-09
+wl=0
+ww=0
+wwl=0
+xl=0
+xw=0
+mobmod=0
+binunit=2
+dwg=-7.916e-09
+dwb=0
+igcmod=0
+igbmod=0
+rgatemod=0
+rbodymod=1
+trnqsmod=0
+acnqsmod=0
+fnoimod=1
+tnoimod=1
+permod=1
+geomod=0
+rdsmod=0
+tempmod=0
+lintnoi=0
+vfbsdoff=0
+lambda=0
+vtl=0
+lc=5e-09
+xn=3
+rnoia=0.69
+rnoib=0.34
+tnoia=2.5e+07
+tnoib=0
+epsrox=3.9
+toxe={4.23e-09+MC_MM_SWITCH*my_gauss*(4.23e-09*(0.003689/sqrt(l*w*m)))}
+dtox=0
+ndep=1.7e+17
+nsd=1e+20
+rshg=0.1
+rsh=1
+vth0={(-4.472146933e-01+MC_MM_SWITCH*my_gauss*(0.01389/sqrt(l*w*m)))*2.55}
+lvth0=-1.58227e-08
+wvth0=7.31655e-08
+pvth0=1.23554e-13
+k1=0.64774
+k2=-0.0556679
+lk2=1.61484e-08
+wk2=5.00783e-08
+pk2=-9.54646e-14
+k3=3.39
+dvt0={2.4422*1}
+dvt1={0.16136*1}
+dvt2=0.026237
+dvt0w=0.5
+dvt1w=1.9281e+06
+dvt2w=-0.032
+w0=1e-08
+k3b=1
+phin=0
+lpe0=0
+lpeb=0
+vbm=-3
+dvtp0=0
+dvtp1=0
+vsat={123760.0*54.1708}
+ua={-2.916032420e-09*1}
+lua=-5.87753e-16
+wua=8.15886e-17
+pua=1.75447e-21
+ub={2.775291051e-18*1}
+lub=1.17749e-24
+wub=3.59128e-25
+pub=-3.51487e-30
+uc={-2.128076763e-12*1}
+luc=1.30554e-16
+wuc=2.17251e-16
+puc=-5.05626e-22
+rdsw={484.7*24.5}
+prwb=0.1
+prwg={0.052*1}
+wr=1
+u0={2.375100637e-03*49.0004}
+lu0=1.10811e-10
+wu0=7.06578e-10
+pu0=-3.88681e-16
+a0=1.38801
+la0=1.28758e-06
+wa0=1.85808e-06
+pa0=-6.46294e-12
+keta=-0.01258
+a1=0
+a2=0.467037
+ags=0.21796
+lags=8.32639e-07
+wags=4.85499e-07
+pags=-2.30141e-12
+b0=0
+b1=2.1073e-24
+eu=1.67
+rdswmin=0
+rdw={1e-12*1}
+rdwmin=0
+rsw={1e-12*1}
+rswmin=0
+voff={-0.1819+MC_MM_SWITCH*my_gauss*(0/sqrt(l*w*m))}
+nfactor={(2.5373+MC_MM_SWITCH*my_gauss*(0/sqrt(l*w*m)))*23}
+up=0
+ud=0
+lp=1
+tvfbsdoff=0
+tvoff=0
+cit=-6.39311e-11
+cdsc=2.8125e-07
+cdscb=0.0001
+cdscd=1e-10
+eta0={0.2*1}
+etab=-0.00025
+dsub={1.0*1}
+voffl=0
+minv=0
+pclm={0.030097*1}
+pdiblc1=0
+pdiblc2=-0.0014673
+lpdiblc2=1.77978e-08
+wpdiblc2=4.40698e-09
+ppdiblc2=-1.46878e-14
+pdiblcb=-0.025
+drout=0.43496
+pscbe1=8e+08
+pscbe2=8.6797e-09
+pvag={1e-12*1}
+delta={1.266017464e-02*1}
+ldelta=8.25564e-09
+wdelta=7.42283e-09
+pdelta=1.23317e-13
+alpha0=5.04495e-13
+alpha1=-4.05837e-18
+beta0=6.20165
+fprout=0
+pdits=0
+pditsl=0
+pditsd=0
+agidl=0
+bgidl=2.3e+09
+cgidl=0.5
+egidl=0.8
+aigbacc=0.43
+bigbacc=0.054
+cigbacc=0.075
+nigbacc=1
+aigbinv=0.35
+bigbinv=0.03
+cigbinv=0.006
+eigbinv=1.1
+nigbinv=3
+aigc=0.43
+bigc=0.054
+cigc=0.075
+nigc=1
+aigsd=0.43
+bigsd=0.054
+cigsd=0.075
+dlcig=0
+poxedge=1
+pigcd=1
+ntox=1
+toxref=4.23e-09
+kt1=0
+kt2=0
+at=0
+lat=0
+wat=0
+pat=0
+ute=0
+ua1=0
+ub1=0
+uc1=0
+kt1l=0
+prt=0
+xrcrg1=12
+xrcrg2=1
+rbpb=50
+rbpd=50
+rbps=50
+rbdb=50
+rbsb=50
+gbmin=1e-12
+noia=3e+41
+noib=0
+noic=0
+em=4.1e+07
+af=1
+ef=0.88
+kf=0
+ntnoi=1
+dmcg=0
+dmcgt=0
+dmdg=0
+xgw=0
+xgl=0
+ngcon=1
+diomod=1
+njs=1.3632
+jss=2.1483e-05
+jsws=1.4472e-10
+xtis=0
+bvs=12.69
+xjbvs=1
+ijthsrev=0.1
+ijthsfwd=0.1
+tpb=0.001671
+tpbsw=0.001246
+tpbswg=0
+tcj=0.0012407
+tcjsw=0.00037357
+tcjswg=2e-12
+cgdo=2e-11
+cgso=2e-11
+cgbo=1e-13
+capmod=2
+xpart=0
+cgsl=0
+cgdl=0
+cf=0
+clc=7e-08
+cle=0.492
+dlc=-1.2e-08
+dwc=0
+vfbcv=-1
+acde=0.44
+moin=8.7
+noff=2.6123
+voffcv=0.112
+ngate=1e+23
+lwc=0
+llc=0
+lwlc=0
+wlc=0
+wwc=0
+wwlc=0
+ckappas=0.6
+cjs=0.000765357
+mjs=0.3362
+pbs=0.6587
+cjsws=9.16024e-11
+mjsws=0.2659
+pbsws=0.7418
+cjswgs=2.39155e-10
+mjswgs=0.9274
+pbswgs=1.4338
+saref=3e-06
+sbref=3e-06
+wlod={0+sky130_fd_pr__pfet_01v8_lvt__wlod_diff}
+kvth0={0+sky130_fd_pr__pfet_01v8_lvt__kvth0_diff}
+lkvth0={0+sky130_fd_pr__pfet_01v8_lvt__lkvth0_diff}
+wkvth0={0+sky130_fd_pr__pfet_01v8_lvt__wkvth0_diff}
+pkvth0=0
+llodvth=0
+wlodvth=1
+stk2=0
+lodk2=1
+lodeta0=1
+ku0={0+sky130_fd_pr__pfet_01v8_lvt__ku0_diff}
+lku0={0+sky130_fd_pr__pfet_01v8_lvt__lku0_diff}
+wku0={0+sky130_fd_pr__pfet_01v8_lvt__wku0_diff}
+pku0=0
+llodku0=0
+wlodku0=1
+kvsat={0+sky130_fd_pr__pfet_01v8_lvt__kvsat_diff}
+steta0=0
+tku0=0
+lkt1=0
+wkt1=0
+pkt1=0
+lkt2=0
+wkt2=0
+pkt2=0
+lute=0
+wute=0
+pute=0
+lua1=0
+wua1=0
+pua1=0
+lub1=0
+wub1=0
+pub1=0
+luc1=0
+wuc1=0
+puc1=0
+ucste=0
+lucste=0
+wucste=0
+pucste=0
* DC IV MOS Parameters
* BSIM4 - Model Selectors
* BSIM4 - Process Parameters
*(mismatch parameter sky130_fd_pr__pfet_01v8_lvt__toxe_slope_spectre)
* Threshold Voltage Parameters
*(mismatch parameter sky130_fd_pr__pfet_01v8_lvt__vth0_slope_spectre)
* NEW BSIM4 Parameters for Level 54
* Mobility Parameters
* BSIM4 - Mobility Parameters
* Subthreshold Current Parameters
*(mismatch parameter sky130_fd_pr__pfet_01v8_lvt__voff_slope_spectre)
*(mismatch parameter sky130_fd_pr__pfet_01v8_lvt__nfactor_slope_spectre)
* BSIM4 - Sub-threshold parameters
* Rout Parameters
* BSIM4 - Rout Parameters
* BSIM4 - Gate Induced Drain Leakage Model Parameters
* BSIM4 - Gate Leakage Current Parameters
* Temperature Effects Parameters
* BSIM4 - High Speed RF Model Parameters
* BSIM4 - Flicker and Thermal Noise Parameters
* BSIM4 - Layout Dependent Parasitic Model Parameters
* Diode DC IV Parameters
* BSIM4 - Diode DC IV parameters
* Diode and FET Capacitance Parameters
* BSIM4 - FET and Diode capacitance parameters
* Stress Parameters

*msky130_fd_pr__pfet_01v8_lvt d g s b sky130_fd_pr__pfet_01v8_lvt__model l=l w=w sa=sa sb=sb sd=sd nf=nf
.ends sky130_fd_pr__pfet_01v8_lvt
